* NGSPICE file created from gear_quantizer.ext - technology: sky130A

* Black-box entry subcircuit for sky130_fd_sc_hd__decap_3 abstract view
.subckt sky130_fd_sc_hd__decap_3 VGND VNB VPB VPWR
.ends

* Black-box entry subcircuit for sky130_fd_sc_hd__o21a_1 abstract view
.subckt sky130_fd_sc_hd__o21a_1 A1 A2 B1 VGND VNB VPB VPWR X
.ends

* Black-box entry subcircuit for sky130_fd_sc_hd__nand2_1 abstract view
.subckt sky130_fd_sc_hd__nand2_1 A B VGND VNB VPB VPWR Y
.ends

* Black-box entry subcircuit for sky130_fd_sc_hd__a22o_1 abstract view
.subckt sky130_fd_sc_hd__a22o_1 A1 A2 B1 B2 VGND VNB VPB VPWR X
.ends

* Black-box entry subcircuit for sky130_fd_sc_hd__and2b_1 abstract view
.subckt sky130_fd_sc_hd__and2b_1 A_N B VGND VNB VPB VPWR X
.ends

* Black-box entry subcircuit for sky130_fd_sc_hd__and2_1 abstract view
.subckt sky130_fd_sc_hd__and2_1 A B VGND VNB VPB VPWR X
.ends

* Black-box entry subcircuit for sky130_fd_sc_hd__a21oi_4 abstract view
.subckt sky130_fd_sc_hd__a21oi_4 A1 A2 B1 VGND VNB VPB VPWR Y
.ends

* Black-box entry subcircuit for sky130_fd_sc_hd__fill_2 abstract view
.subckt sky130_fd_sc_hd__fill_2 VGND VNB VPB VPWR
.ends

* Black-box entry subcircuit for sky130_ef_sc_hd__decap_12 abstract view
.subckt sky130_ef_sc_hd__decap_12 VPWR VGND VPB VNB
.ends

* Black-box entry subcircuit for sky130_fd_sc_hd__nand4_1 abstract view
.subckt sky130_fd_sc_hd__nand4_1 A B C D VGND VNB VPB VPWR Y
.ends

* Black-box entry subcircuit for sky130_fd_sc_hd__decap_6 abstract view
.subckt sky130_fd_sc_hd__decap_6 VGND VNB VPB VPWR
.ends

* Black-box entry subcircuit for sky130_fd_sc_hd__clkbuf_4 abstract view
.subckt sky130_fd_sc_hd__clkbuf_4 A VGND VNB VPB VPWR X
.ends

* Black-box entry subcircuit for sky130_fd_sc_hd__tapvpwrvgnd_1 abstract view
.subckt sky130_fd_sc_hd__tapvpwrvgnd_1 VGND VPWR
.ends

* Black-box entry subcircuit for sky130_fd_sc_hd__fill_1 abstract view
.subckt sky130_fd_sc_hd__fill_1 VGND VNB VPB VPWR
.ends

* Black-box entry subcircuit for sky130_fd_sc_hd__decap_8 abstract view
.subckt sky130_fd_sc_hd__decap_8 VGND VNB VPB VPWR
.ends

* Black-box entry subcircuit for sky130_fd_sc_hd__buf_2 abstract view
.subckt sky130_fd_sc_hd__buf_2 A VGND VNB VPB VPWR X
.ends

* Black-box entry subcircuit for sky130_fd_sc_hd__a41o_1 abstract view
.subckt sky130_fd_sc_hd__a41o_1 A1 A2 A3 A4 B1 VGND VNB VPB VPWR X
.ends

* Black-box entry subcircuit for sky130_fd_sc_hd__a21o_1 abstract view
.subckt sky130_fd_sc_hd__a21o_1 A1 A2 B1 VGND VNB VPB VPWR X
.ends

* Black-box entry subcircuit for sky130_fd_sc_hd__o22a_1 abstract view
.subckt sky130_fd_sc_hd__o22a_1 A1 A2 B1 B2 VGND VNB VPB VPWR X
.ends

* Black-box entry subcircuit for sky130_fd_sc_hd__or2_1 abstract view
.subckt sky130_fd_sc_hd__or2_1 A B VGND VNB VPB VPWR X
.ends

* Black-box entry subcircuit for sky130_fd_sc_hd__decap_4 abstract view
.subckt sky130_fd_sc_hd__decap_4 VGND VNB VPB VPWR
.ends

* Black-box entry subcircuit for sky130_fd_sc_hd__or4b_1 abstract view
.subckt sky130_fd_sc_hd__or4b_1 A B C D_N VGND VNB VPB VPWR X
.ends

* Black-box entry subcircuit for sky130_fd_sc_hd__and4_1 abstract view
.subckt sky130_fd_sc_hd__and4_1 A B C D VGND VNB VPB VPWR X
.ends

* Black-box entry subcircuit for sky130_fd_sc_hd__nand3_1 abstract view
.subckt sky130_fd_sc_hd__nand3_1 A B C VGND VNB VPB VPWR Y
.ends

* Black-box entry subcircuit for sky130_fd_sc_hd__o221a_1 abstract view
.subckt sky130_fd_sc_hd__o221a_1 A1 A2 B1 B2 C1 VGND VNB VPB VPWR X
.ends

* Black-box entry subcircuit for sky130_fd_sc_hd__xor2_1 abstract view
.subckt sky130_fd_sc_hd__xor2_1 A B VGND VNB VPB VPWR X
.ends

* Black-box entry subcircuit for sky130_fd_sc_hd__dlygate4sd3_1 abstract view
.subckt sky130_fd_sc_hd__dlygate4sd3_1 A VGND VNB VPB VPWR X
.ends

* Black-box entry subcircuit for sky130_fd_sc_hd__or3_1 abstract view
.subckt sky130_fd_sc_hd__or3_1 A B C VGND VNB VPB VPWR X
.ends

* Black-box entry subcircuit for sky130_fd_sc_hd__dfrtp_1 abstract view
.subckt sky130_fd_sc_hd__dfrtp_1 CLK D RESET_B VGND VNB VPB VPWR Q
.ends

* Black-box entry subcircuit for sky130_fd_sc_hd__inv_2 abstract view
.subckt sky130_fd_sc_hd__inv_2 A VGND VNB VPB VPWR Y
.ends

* Black-box entry subcircuit for sky130_fd_sc_hd__and3_1 abstract view
.subckt sky130_fd_sc_hd__and3_1 A B C VGND VNB VPB VPWR X
.ends

* Black-box entry subcircuit for sky130_fd_sc_hd__or2b_1 abstract view
.subckt sky130_fd_sc_hd__or2b_1 A B_N VGND VNB VPB VPWR X
.ends

* Black-box entry subcircuit for sky130_fd_sc_hd__o211a_1 abstract view
.subckt sky130_fd_sc_hd__o211a_1 A1 A2 B1 C1 VGND VNB VPB VPWR X
.ends

* Black-box entry subcircuit for sky130_fd_sc_hd__xnor2_1 abstract view
.subckt sky130_fd_sc_hd__xnor2_1 A B VGND VNB VPB VPWR Y
.ends

* Black-box entry subcircuit for sky130_fd_sc_hd__nor2_2 abstract view
.subckt sky130_fd_sc_hd__nor2_2 A B VGND VNB VPB VPWR Y
.ends

* Black-box entry subcircuit for sky130_fd_sc_hd__or3b_1 abstract view
.subckt sky130_fd_sc_hd__or3b_1 A B C_N VGND VNB VPB VPWR X
.ends

* Black-box entry subcircuit for sky130_fd_sc_hd__a31o_1 abstract view
.subckt sky130_fd_sc_hd__a31o_1 A1 A2 A3 B1 VGND VNB VPB VPWR X
.ends

* Black-box entry subcircuit for sky130_fd_sc_hd__clkbuf_16 abstract view
.subckt sky130_fd_sc_hd__clkbuf_16 A VGND VNB VPB VPWR X
.ends

* Black-box entry subcircuit for sky130_fd_sc_hd__o21bai_1 abstract view
.subckt sky130_fd_sc_hd__o21bai_1 A1 A2 B1_N VGND VNB VPB VPWR Y
.ends

* Black-box entry subcircuit for sky130_fd_sc_hd__or3b_2 abstract view
.subckt sky130_fd_sc_hd__or3b_2 A B C_N VGND VNB VPB VPWR X
.ends

* Black-box entry subcircuit for sky130_fd_sc_hd__a21oi_1 abstract view
.subckt sky130_fd_sc_hd__a21oi_1 A1 A2 B1 VGND VNB VPB VPWR Y
.ends

* Black-box entry subcircuit for sky130_fd_sc_hd__o311ai_4 abstract view
.subckt sky130_fd_sc_hd__o311ai_4 A1 A2 A3 B1 C1 VGND VNB VPB VPWR Y
.ends

* Black-box entry subcircuit for sky130_fd_sc_hd__nand4_2 abstract view
.subckt sky130_fd_sc_hd__nand4_2 A B C D VGND VNB VPB VPWR Y
.ends

* Black-box entry subcircuit for sky130_fd_sc_hd__o211ai_2 abstract view
.subckt sky130_fd_sc_hd__o211ai_2 A1 A2 B1 C1 VGND VNB VPB VPWR Y
.ends

* Black-box entry subcircuit for sky130_fd_sc_hd__nor2_1 abstract view
.subckt sky130_fd_sc_hd__nor2_1 A B VGND VNB VPB VPWR Y
.ends

* Black-box entry subcircuit for sky130_fd_sc_hd__nor4_1 abstract view
.subckt sky130_fd_sc_hd__nor4_1 A B C D VGND VNB VPB VPWR Y
.ends

* Black-box entry subcircuit for sky130_fd_sc_hd__buf_1 abstract view
.subckt sky130_fd_sc_hd__buf_1 A VGND VNB VPB VPWR X
.ends

* Black-box entry subcircuit for sky130_fd_sc_hd__mux2_1 abstract view
.subckt sky130_fd_sc_hd__mux2_1 A0 A1 S VGND VNB VPB VPWR X
.ends

* Black-box entry subcircuit for sky130_fd_sc_hd__nand2_2 abstract view
.subckt sky130_fd_sc_hd__nand2_2 A B VGND VNB VPB VPWR Y
.ends

* Black-box entry subcircuit for sky130_fd_sc_hd__dlymetal6s2s_1 abstract view
.subckt sky130_fd_sc_hd__dlymetal6s2s_1 A VGND VNB VPB VPWR X
.ends

* Black-box entry subcircuit for sky130_fd_sc_hd__and4b_1 abstract view
.subckt sky130_fd_sc_hd__and4b_1 A_N B C D VGND VNB VPB VPWR X
.ends

* Black-box entry subcircuit for sky130_fd_sc_hd__o31a_1 abstract view
.subckt sky130_fd_sc_hd__o31a_1 A1 A2 A3 B1 VGND VNB VPB VPWR X
.ends

* Black-box entry subcircuit for sky130_fd_sc_hd__and3_2 abstract view
.subckt sky130_fd_sc_hd__and3_2 A B C VGND VNB VPB VPWR X
.ends

* Black-box entry subcircuit for sky130_fd_sc_hd__clkbuf_2 abstract view
.subckt sky130_fd_sc_hd__clkbuf_2 A VGND VNB VPB VPWR X
.ends

* Black-box entry subcircuit for sky130_fd_sc_hd__o21ai_1 abstract view
.subckt sky130_fd_sc_hd__o21ai_1 A1 A2 B1 VGND VNB VPB VPWR Y
.ends

* Black-box entry subcircuit for sky130_fd_sc_hd__xnor2_2 abstract view
.subckt sky130_fd_sc_hd__xnor2_2 A B VGND VNB VPB VPWR Y
.ends

* Black-box entry subcircuit for sky130_fd_sc_hd__xor2_2 abstract view
.subckt sky130_fd_sc_hd__xor2_2 A B VGND VNB VPB VPWR X
.ends

* Black-box entry subcircuit for sky130_fd_sc_hd__clkbuf_1 abstract view
.subckt sky130_fd_sc_hd__clkbuf_1 A VGND VNB VPB VPWR X
.ends

* Black-box entry subcircuit for sky130_fd_sc_hd__nor2b_2 abstract view
.subckt sky130_fd_sc_hd__nor2b_2 A B_N VGND VNB VPB VPWR Y
.ends

* Black-box entry subcircuit for sky130_fd_sc_hd__a211o_1 abstract view
.subckt sky130_fd_sc_hd__a211o_1 A1 A2 B1 C1 VGND VNB VPB VPWR X
.ends

* Black-box entry subcircuit for sky130_fd_sc_hd__buf_4 abstract view
.subckt sky130_fd_sc_hd__buf_4 A VGND VNB VPB VPWR X
.ends

* Black-box entry subcircuit for sky130_fd_sc_hd__a21boi_2 abstract view
.subckt sky130_fd_sc_hd__a21boi_2 A1 A2 B1_N VGND VNB VPB VPWR Y
.ends

* Black-box entry subcircuit for sky130_fd_sc_hd__a21bo_1 abstract view
.subckt sky130_fd_sc_hd__a21bo_1 A1 A2 B1_N VGND VNB VPB VPWR X
.ends

* Black-box entry subcircuit for sky130_fd_sc_hd__or4_1 abstract view
.subckt sky130_fd_sc_hd__or4_1 A B C D VGND VNB VPB VPWR X
.ends

* Black-box entry subcircuit for sky130_fd_sc_hd__o21ai_2 abstract view
.subckt sky130_fd_sc_hd__o21ai_2 A1 A2 B1 VGND VNB VPB VPWR Y
.ends

* Black-box entry subcircuit for sky130_fd_sc_hd__a211oi_1 abstract view
.subckt sky130_fd_sc_hd__a211oi_1 A1 A2 B1 C1 VGND VNB VPB VPWR Y
.ends

* Black-box entry subcircuit for sky130_fd_sc_hd__a32o_1 abstract view
.subckt sky130_fd_sc_hd__a32o_1 A1 A2 A3 B1 B2 VGND VNB VPB VPWR X
.ends

* Black-box entry subcircuit for sky130_fd_sc_hd__a21oi_2 abstract view
.subckt sky130_fd_sc_hd__a21oi_2 A1 A2 B1 VGND VNB VPB VPWR Y
.ends

* Black-box entry subcircuit for sky130_fd_sc_hd__nand3_2 abstract view
.subckt sky130_fd_sc_hd__nand3_2 A B C VGND VNB VPB VPWR Y
.ends

* Black-box entry subcircuit for sky130_fd_sc_hd__o21ba_1 abstract view
.subckt sky130_fd_sc_hd__o21ba_1 A1 A2 B1_N VGND VNB VPB VPWR X
.ends

.subckt gear_quantizer VGND VPWR clk data_in[0] data_in[1] data_in[2] data_in[3] data_in[4]
+ data_in[5] data_in[6] data_in[7] int4_out[0] int4_out[1] int4_out[2] int4_out[3]
+ is_outlier round_mode rst_n scale[0] scale[1] scale[2] scale[3] sideband_out[0]
+ sideband_out[1] sideband_out[2] sideband_out[3] sideband_out[4] sideband_out[5]
+ sideband_out[6] sideband_out[7] threshold[0] threshold[1] threshold[2] threshold[3]
+ threshold[4] threshold[5] threshold[6] threshold[7] valid_in valid_out
XFILLER_0_23_18 VGND VGND VPWR VPWR sky130_fd_sc_hd__decap_3
X_432_ _060_ _138_ _062_ VGND VGND VPWR VPWR _155_ sky130_fd_sc_hd__o21a_1
X_294_ _200_ _016_ VGND VGND VPWR VPWR _017_ sky130_fd_sc_hd__nand2_1
X_363_ _020_ net2 net1 net14 VGND VGND VPWR VPWR _086_ sky130_fd_sc_hd__a22o_1
X_415_ _065_ _077_ VGND VGND VPWR VPWR _138_ sky130_fd_sc_hd__and2b_1
X_346_ net12 _194_ VGND VGND VPWR VPWR _069_ sky130_fd_sc_hd__and2_1
X_277_ net22 _201_ _226_ VGND VGND VPWR VPWR _227_ sky130_fd_sc_hd__a21oi_4
XFILLER_0_4_82 VGND VGND VPWR VPWR sky130_fd_sc_hd__fill_2
XFILLER_0_28_169 VGND VGND VPWR VPWR sky130_fd_sc_hd__fill_2
XFILLER_0_28_147 VPWR VGND VPWR VGND sky130_ef_sc_hd__decap_12
XFILLER_0_28_125 VPWR VGND VPWR VGND sky130_ef_sc_hd__decap_12
X_329_ net14 _020_ _194_ net4 VGND VGND VPWR VPWR _052_ sky130_fd_sc_hd__nand4_1
XFILLER_0_9_27 VPWR VGND VPWR VGND sky130_ef_sc_hd__decap_12
XFILLER_0_19_169 VGND VGND VPWR VPWR sky130_fd_sc_hd__fill_2
XFILLER_0_26_29 VPWR VGND VPWR VGND sky130_ef_sc_hd__decap_12
XFILLER_0_15_161 VGND VGND VPWR VPWR sky130_fd_sc_hd__decap_6
XFILLER_0_12_153 VPWR VGND VPWR VGND sky130_ef_sc_hd__decap_12
Xoutput31 net31 VGND VGND VPWR VPWR sideband_out[2] sky130_fd_sc_hd__clkbuf_4
XTAP_145 VGND VPWR sky130_fd_sc_hd__tapvpwrvgnd_1
XTAP_134 VGND VPWR sky130_fd_sc_hd__tapvpwrvgnd_1
XTAP_123 VGND VPWR sky130_fd_sc_hd__tapvpwrvgnd_1
XTAP_112 VGND VPWR sky130_fd_sc_hd__tapvpwrvgnd_1
XTAP_101 VGND VPWR sky130_fd_sc_hd__tapvpwrvgnd_1
XFILLER_0_7_60 VGND VGND VPWR VPWR sky130_fd_sc_hd__fill_1
XFILLER_0_7_82 VGND VGND VPWR VPWR sky130_fd_sc_hd__decap_8
X_431_ _038_ _044_ VGND VGND VPWR VPWR _154_ sky130_fd_sc_hd__nand2_1
XFILLER_0_2_109 VPWR VGND VPWR VGND sky130_ef_sc_hd__decap_12
X_293_ net12 VGND VGND VPWR VPWR _016_ sky130_fd_sc_hd__buf_2
X_362_ _230_ _020_ net2 net1 VGND VGND VPWR VPWR _085_ sky130_fd_sc_hd__nand4_1
XFILLER_0_13_30 VGND VGND VPWR VPWR sky130_fd_sc_hd__fill_1
X_414_ _100_ _123_ _131_ _134_ _136_ VGND VGND VPWR VPWR _137_ sky130_fd_sc_hd__a41o_1
X_345_ _052_ _051_ _050_ VGND VGND VPWR VPWR _068_ sky130_fd_sc_hd__a21o_1
X_276_ net22 _201_ _204_ _225_ VGND VGND VPWR VPWR _226_ sky130_fd_sc_hd__o22a_1
XFILLER_0_28_137 VGND VGND VPWR VPWR sky130_fd_sc_hd__decap_3
X_328_ _020_ net5 net4 net14 VGND VGND VPWR VPWR _051_ sky130_fd_sc_hd__a22o_1
X_259_ net19 _208_ VGND VGND VPWR VPWR _209_ sky130_fd_sc_hd__or2_1
XFILLER_0_9_39 VGND VGND VPWR VPWR sky130_fd_sc_hd__fill_1
XFILLER_0_19_104 VGND VGND VPWR VPWR sky130_fd_sc_hd__decap_8
XFILLER_0_19_62 VGND VGND VPWR VPWR sky130_fd_sc_hd__fill_1
XFILLER_0_10_42 VGND VGND VPWR VPWR sky130_fd_sc_hd__fill_2
XFILLER_0_10_75 VGND VGND VPWR VPWR sky130_fd_sc_hd__fill_2
XFILLER_0_21_74 VPWR VGND VPWR VGND sky130_ef_sc_hd__decap_12
XFILLER_0_27_3 VPWR VGND VPWR VGND sky130_ef_sc_hd__decap_12
XFILLER_0_21_132 VGND VGND VPWR VPWR sky130_fd_sc_hd__fill_1
XFILLER_0_16_96 VGND VGND VPWR VPWR sky130_fd_sc_hd__fill_2
XFILLER_0_16_74 VGND VGND VPWR VPWR sky130_fd_sc_hd__fill_2
XFILLER_0_12_165 VGND VGND VPWR VPWR sky130_fd_sc_hd__decap_6
XFILLER_0_12_121 VPWR VGND VPWR VGND sky130_ef_sc_hd__decap_12
Xoutput32 net32 VGND VGND VPWR VPWR sideband_out[3] sky130_fd_sc_hd__clkbuf_4
XTAP_146 VGND VPWR sky130_fd_sc_hd__tapvpwrvgnd_1
XFILLER_0_27_73 VGND VGND VPWR VPWR sky130_fd_sc_hd__fill_2
XFILLER_0_27_51 VGND VGND VPWR VPWR sky130_fd_sc_hd__decap_4
XTAP_135 VGND VPWR sky130_fd_sc_hd__tapvpwrvgnd_1
XTAP_124 VGND VPWR sky130_fd_sc_hd__tapvpwrvgnd_1
XTAP_113 VGND VPWR sky130_fd_sc_hd__tapvpwrvgnd_1
XTAP_102 VGND VPWR sky130_fd_sc_hd__tapvpwrvgnd_1
X_430_ _038_ _044_ VGND VGND VPWR VPWR _153_ sky130_fd_sc_hd__or2_1
X_292_ _232_ _236_ _013_ _014_ VGND VGND VPWR VPWR _015_ sky130_fd_sc_hd__or4b_1
X_361_ _230_ _231_ _196_ _197_ VGND VGND VPWR VPWR _084_ sky130_fd_sc_hd__and4_1
X_413_ _133_ _135_ VGND VGND VPWR VPWR _136_ sky130_fd_sc_hd__and2_1
X_344_ _052_ _050_ _051_ VGND VGND VPWR VPWR _067_ sky130_fd_sc_hd__nand3_1
X_275_ net21 _203_ _206_ net20 _224_ VGND VGND VPWR VPWR _225_ sky130_fd_sc_hd__o221a_1
XFILLER_0_24_85 VGND VGND VPWR VPWR sky130_fd_sc_hd__fill_2
XFILLER_0_19_127 VPWR VGND VPWR VGND sky130_ef_sc_hd__decap_12
X_327_ net12 net6 VGND VGND VPWR VPWR _050_ sky130_fd_sc_hd__and2_1
X_258_ _194_ _207_ VGND VGND VPWR VPWR _208_ sky130_fd_sc_hd__xor2_1
XFILLER_0_24_141 VPWR VGND VPWR VGND sky130_ef_sc_hd__decap_12
XFILLER_0_21_86 VGND VGND VPWR VPWR sky130_fd_sc_hd__fill_1
XFILLER_0_21_111 VGND VGND VPWR VPWR sky130_fd_sc_hd__fill_1
Xhold10 net31 VGND VGND VPWR VPWR net49 sky130_fd_sc_hd__dlygate4sd3_1
XFILLER_0_12_133 VGND VGND VPWR VPWR sky130_fd_sc_hd__decap_6
XFILLER_0_8_138 VGND VGND VPWR VPWR sky130_fd_sc_hd__fill_2
Xoutput33 net33 VGND VGND VPWR VPWR sideband_out[4] sky130_fd_sc_hd__buf_2
XFILLER_0_9_3 VPWR VGND VPWR VGND sky130_ef_sc_hd__decap_12
XTAP_147 VGND VPWR sky130_fd_sc_hd__tapvpwrvgnd_1
XTAP_136 VGND VPWR sky130_fd_sc_hd__tapvpwrvgnd_1
XTAP_125 VGND VPWR sky130_fd_sc_hd__tapvpwrvgnd_1
XTAP_114 VGND VPWR sky130_fd_sc_hd__tapvpwrvgnd_1
XTAP_103 VGND VPWR sky130_fd_sc_hd__tapvpwrvgnd_1
X_291_ _237_ _233_ _238_ VGND VGND VPWR VPWR _014_ sky130_fd_sc_hd__or3_1
X_360_ _079_ _080_ _081_ VGND VGND VPWR VPWR _083_ sky130_fd_sc_hd__a21o_1
XFILLER_0_4_141 VPWR VGND VPWR VGND sky130_ef_sc_hd__decap_12
XFILLER_0_13_54 VGND VGND VPWR VPWR sky130_fd_sc_hd__fill_2
X_489_ clknet_1_0__leaf_clk _010_ net39 VGND VGND VPWR VPWR net34 sky130_fd_sc_hd__dfrtp_1
XFILLER_0_1_111 VGND VGND VPWR VPWR sky130_fd_sc_hd__fill_1
X_412_ _098_ _129_ _128_ VGND VGND VPWR VPWR _135_ sky130_fd_sc_hd__a21o_1
X_343_ net11 _192_ VGND VGND VPWR VPWR _066_ sky130_fd_sc_hd__nand2_1
XFILLER_0_0_7 VGND VGND VPWR VPWR sky130_fd_sc_hd__fill_1
X_274_ net20 _206_ _209_ _223_ VGND VGND VPWR VPWR _224_ sky130_fd_sc_hd__a22o_1
XFILLER_0_24_20 VGND VGND VPWR VPWR sky130_fd_sc_hd__decap_8
XFILLER_0_4_74 VGND VGND VPWR VPWR sky130_fd_sc_hd__decap_8
XFILLER_0_4_85 VPWR VGND VPWR VGND sky130_ef_sc_hd__decap_12
X_326_ _048_ VGND VGND VPWR VPWR _049_ sky130_fd_sc_hd__inv_2
X_257_ _200_ _198_ VGND VGND VPWR VPWR _207_ sky130_fd_sc_hd__nand2_1
XFILLER_0_10_66 VGND VGND VPWR VPWR sky130_fd_sc_hd__fill_2
XFILLER_0_19_139 VPWR VGND VPWR VGND sky130_ef_sc_hd__decap_12
X_309_ _200_ _030_ _031_ VGND VGND VPWR VPWR _032_ sky130_fd_sc_hd__and3_1
XFILLER_0_24_153 VPWR VGND VPWR VGND sky130_ef_sc_hd__decap_12
XFILLER_0_21_65 VGND VGND VPWR VPWR sky130_fd_sc_hd__fill_2
XFILLER_0_1_31 VPWR VGND VPWR VGND sky130_ef_sc_hd__decap_12
Xhold11 net33 VGND VGND VPWR VPWR net50 sky130_fd_sc_hd__dlygate4sd3_1
XFILLER_0_8_117 VGND VGND VPWR VPWR sky130_fd_sc_hd__fill_1
Xoutput34 net34 VGND VGND VPWR VPWR sideband_out[5] sky130_fd_sc_hd__clkbuf_4
XTAP_148 VGND VPWR sky130_fd_sc_hd__tapvpwrvgnd_1
XTAP_137 VGND VPWR sky130_fd_sc_hd__tapvpwrvgnd_1
XTAP_126 VGND VPWR sky130_fd_sc_hd__tapvpwrvgnd_1
XTAP_115 VGND VPWR sky130_fd_sc_hd__tapvpwrvgnd_1
XTAP_104 VGND VPWR sky130_fd_sc_hd__tapvpwrvgnd_1
XFILLER_0_4_153 VPWR VGND VPWR VGND sky130_ef_sc_hd__decap_12
X_290_ _237_ _238_ _233_ VGND VGND VPWR VPWR _013_ sky130_fd_sc_hd__o21a_1
X_488_ clknet_1_0__leaf_clk _009_ net10 VGND VGND VPWR VPWR net33 sky130_fd_sc_hd__dfrtp_1
XFILLER_0_1_167 VGND VGND VPWR VPWR sky130_fd_sc_hd__fill_1
X_411_ _128_ _133_ VGND VGND VPWR VPWR _134_ sky130_fd_sc_hd__xor2_1
X_342_ _060_ _064_ VGND VGND VPWR VPWR _065_ sky130_fd_sc_hd__or2b_1
X_273_ net19 _208_ _212_ _222_ VGND VGND VPWR VPWR _223_ sky130_fd_sc_hd__a22o_1
XFILLER_0_24_54 VGND VGND VPWR VPWR sky130_fd_sc_hd__decap_3
XFILLER_0_4_97 VPWR VGND VPWR VGND sky130_ef_sc_hd__decap_12
XFILLER_0_28_107 VGND VGND VPWR VPWR sky130_fd_sc_hd__decap_4
XFILLER_0_19_76 VGND VGND VPWR VPWR sky130_fd_sc_hd__decap_3
X_325_ _229_ _015_ _046_ _047_ VGND VGND VPWR VPWR _048_ sky130_fd_sc_hd__o211a_1
X_256_ _193_ _205_ VGND VGND VPWR VPWR _206_ sky130_fd_sc_hd__xnor2_1
XFILLER_0_24_165 VGND VGND VPWR VPWR sky130_fd_sc_hd__decap_6
X_308_ _028_ _023_ VGND VGND VPWR VPWR _031_ sky130_fd_sc_hd__xnor2_1
X_239_ net23 VGND VGND VPWR VPWR _189_ sky130_fd_sc_hd__clkbuf_4
XFILLER_0_1_43 VPWR VGND VPWR VGND sky130_ef_sc_hd__decap_12
Xhold12 net34 VGND VGND VPWR VPWR net51 sky130_fd_sc_hd__dlygate4sd3_1
XFILLER_0_21_113 VGND VGND VPWR VPWR sky130_fd_sc_hd__fill_1
XFILLER_0_16_88 VGND VGND VPWR VPWR sky130_fd_sc_hd__decap_8
XFILLER_0_25_3 VPWR VGND VPWR VGND sky130_ef_sc_hd__decap_12
Xoutput24 net24 VGND VGND VPWR VPWR int4_out[0] sky130_fd_sc_hd__clkbuf_4
Xoutput35 net35 VGND VGND VPWR VPWR sideband_out[6] sky130_fd_sc_hd__clkbuf_4
XFILLER_0_7_151 VPWR VGND VPWR VGND sky130_ef_sc_hd__decap_12
XTAP_149 VGND VPWR sky130_fd_sc_hd__tapvpwrvgnd_1
XTAP_138 VGND VPWR sky130_fd_sc_hd__tapvpwrvgnd_1
XTAP_127 VGND VPWR sky130_fd_sc_hd__tapvpwrvgnd_1
XTAP_116 VGND VPWR sky130_fd_sc_hd__tapvpwrvgnd_1
XTAP_105 VGND VPWR sky130_fd_sc_hd__tapvpwrvgnd_1
XFILLER_0_4_165 VGND VGND VPWR VPWR sky130_fd_sc_hd__decap_6
X_487_ clknet_1_1__leaf_clk _008_ net10 VGND VGND VPWR VPWR net32 sky130_fd_sc_hd__dfrtp_1
XFILLER_0_1_113 VPWR VGND VPWR VGND sky130_ef_sc_hd__decap_12
X_410_ _077_ _132_ VGND VGND VPWR VPWR _133_ sky130_fd_sc_hd__nor2_2
X_341_ _059_ _056_ _058_ VGND VGND VPWR VPWR _064_ sky130_fd_sc_hd__or3b_1
X_272_ net18 _211_ _215_ _221_ VGND VGND VPWR VPWR _222_ sky130_fd_sc_hd__a22o_1
XFILLER_0_24_11 VGND VGND VPWR VPWR sky130_fd_sc_hd__fill_2
X_324_ _016_ _237_ _229_ VGND VGND VPWR VPWR _047_ sky130_fd_sc_hd__nand3_1
X_255_ _194_ _198_ _200_ VGND VGND VPWR VPWR _205_ sky130_fd_sc_hd__o21a_1
XFILLER_0_18_141 VPWR VGND VPWR VGND sky130_ef_sc_hd__decap_12
X_307_ net11 VGND VGND VPWR VPWR _030_ sky130_fd_sc_hd__buf_2
XFILLER_0_1_55 VGND VGND VPWR VPWR sky130_fd_sc_hd__fill_1
XFILLER_0_21_169 VGND VGND VPWR VPWR sky130_fd_sc_hd__fill_2
XFILLER_0_21_147 VPWR VGND VPWR VGND sky130_ef_sc_hd__decap_12
XFILLER_0_21_103 VGND VGND VPWR VPWR sky130_fd_sc_hd__decap_8
XFILLER_0_16_67 VGND VGND VPWR VPWR sky130_fd_sc_hd__fill_2
XFILLER_0_18_3 VPWR VGND VPWR VGND sky130_ef_sc_hd__decap_12
XFILLER_0_7_130 VGND VGND VPWR VPWR sky130_fd_sc_hd__fill_1
XFILLER_0_7_163 VGND VGND VPWR VPWR sky130_fd_sc_hd__decap_4
Xoutput25 net25 VGND VGND VPWR VPWR int4_out[1] sky130_fd_sc_hd__clkbuf_4
Xoutput36 net36 VGND VGND VPWR VPWR sideband_out[7] sky130_fd_sc_hd__clkbuf_4
XFILLER_0_27_55 VGND VGND VPWR VPWR sky130_fd_sc_hd__fill_1
XTAP_139 VGND VPWR sky130_fd_sc_hd__tapvpwrvgnd_1
XTAP_128 VGND VPWR sky130_fd_sc_hd__tapvpwrvgnd_1
XTAP_117 VGND VPWR sky130_fd_sc_hd__tapvpwrvgnd_1
XTAP_106 VGND VPWR sky130_fd_sc_hd__tapvpwrvgnd_1
XPHY_0 VGND VGND VPWR VPWR sky130_fd_sc_hd__decap_3
XFILLER_0_7_98 VGND VGND VPWR VPWR sky130_fd_sc_hd__decap_6
XFILLER_0_1_169 VGND VGND VPWR VPWR sky130_fd_sc_hd__fill_2
XFILLER_0_1_125 VPWR VGND VPWR VGND sky130_ef_sc_hd__decap_12
X_486_ clknet_1_0__leaf_clk _007_ net10 VGND VGND VPWR VPWR net31 sky130_fd_sc_hd__dfrtp_1
XFILLER_0_24_67 VGND VGND VPWR VPWR sky130_fd_sc_hd__decap_4
X_340_ _060_ _062_ VGND VGND VPWR VPWR _063_ sky130_fd_sc_hd__xor2_1
X_271_ net17 _214_ _219_ _220_ VGND VGND VPWR VPWR _221_ sky130_fd_sc_hd__a22o_1
X_469_ net4 _189_ _227_ _184_ VGND VGND VPWR VPWR _008_ sky130_fd_sc_hd__a31o_1
X_323_ _018_ _045_ VGND VGND VPWR VPWR _046_ sky130_fd_sc_hd__xnor2_1
X_254_ net21 _203_ VGND VGND VPWR VPWR _204_ sky130_fd_sc_hd__and2_1
XFILLER_0_27_164 VGND VGND VPWR VPWR sky130_fd_sc_hd__fill_1
XFILLER_0_27_120 VPWR VGND VPWR VGND sky130_ef_sc_hd__decap_12
XFILLER_0_10_58 VGND VGND VPWR VPWR sky130_fd_sc_hd__fill_1
XFILLER_0_18_153 VPWR VGND VPWR VGND sky130_ef_sc_hd__decap_12
XFILLER_0_21_57 VGND VGND VPWR VPWR sky130_fd_sc_hd__fill_1
XFILLER_0_21_13 VPWR VGND VPWR VGND sky130_ef_sc_hd__decap_12
X_306_ _023_ _028_ VGND VGND VPWR VPWR _029_ sky130_fd_sc_hd__and2b_1
XFILLER_0_15_167 VGND VGND VPWR VPWR sky130_fd_sc_hd__fill_1
XFILLER_0_21_159 VGND VGND VPWR VPWR sky130_fd_sc_hd__decap_3
XFILLER_0_8_109 VGND VGND VPWR VPWR sky130_fd_sc_hd__decap_8
XFILLER_0_12_115 VGND VGND VPWR VPWR sky130_fd_sc_hd__decap_3
Xoutput26 net26 VGND VGND VPWR VPWR int4_out[2] sky130_fd_sc_hd__clkbuf_4
Xoutput37 net37 VGND VGND VPWR VPWR valid_out sky130_fd_sc_hd__clkbuf_4
XTAP_129 VGND VPWR sky130_fd_sc_hd__tapvpwrvgnd_1
XTAP_118 VGND VPWR sky130_fd_sc_hd__tapvpwrvgnd_1
XTAP_107 VGND VPWR sky130_fd_sc_hd__tapvpwrvgnd_1
XPHY_1 VGND VGND VPWR VPWR sky130_fd_sc_hd__decap_3
XFILLER_0_4_134 VGND VGND VPWR VPWR sky130_fd_sc_hd__decap_6
XFILLER_0_7_55 VGND VGND VPWR VPWR sky130_fd_sc_hd__fill_1
XFILLER_0_13_69 VGND VGND VPWR VPWR sky130_fd_sc_hd__fill_2
XFILLER_0_1_137 VPWR VGND VPWR VGND sky130_ef_sc_hd__decap_12
X_485_ clknet_1_0__leaf_clk _006_ net10 VGND VGND VPWR VPWR net30 sky130_fd_sc_hd__dfrtp_1
X_270_ net16 _217_ VGND VGND VPWR VPWR _220_ sky130_fd_sc_hd__or2_1
X_468_ _191_ net32 VGND VGND VPWR VPWR _184_ sky130_fd_sc_hd__and2_1
X_399_ _108_ _111_ VGND VGND VPWR VPWR _122_ sky130_fd_sc_hd__and2_1
X_322_ _038_ _044_ _042_ VGND VGND VPWR VPWR _045_ sky130_fd_sc_hd__o21a_1
XFILLER_0_14_90 VGND VGND VPWR VPWR sky130_fd_sc_hd__decap_8
XFILLER_0_27_132 VPWR VGND VPWR VGND sky130_ef_sc_hd__decap_12
X_253_ _192_ _202_ VGND VGND VPWR VPWR _203_ sky130_fd_sc_hd__xor2_1
XFILLER_0_10_15 VPWR VGND VPWR VGND sky130_ef_sc_hd__decap_12
XFILLER_0_18_165 VGND VGND VPWR VPWR sky130_fd_sc_hd__decap_6
XFILLER_0_21_25 VGND VGND VPWR VPWR sky130_fd_sc_hd__decap_4
X_305_ _026_ _027_ VGND VGND VPWR VPWR _028_ sky130_fd_sc_hd__and2_1
XFILLER_0_15_113 VGND VGND VPWR VPWR sky130_fd_sc_hd__decap_4
XFILLER_0_1_57 VPWR VGND VPWR VGND sky130_ef_sc_hd__decap_12
Xoutput27 net27 VGND VGND VPWR VPWR int4_out[3] sky130_fd_sc_hd__clkbuf_4
XFILLER_0_27_57 VGND VGND VPWR VPWR sky130_fd_sc_hd__decap_3
XTAP_119 VGND VPWR sky130_fd_sc_hd__tapvpwrvgnd_1
XTAP_108 VGND VPWR sky130_fd_sc_hd__tapvpwrvgnd_1
Xclkbuf_0_clk clk VGND VGND VPWR VPWR clknet_0_clk sky130_fd_sc_hd__clkbuf_16
XPHY_2 VGND VGND VPWR VPWR sky130_fd_sc_hd__decap_3
XFILLER_0_23_3 VGND VGND VPWR VPWR sky130_fd_sc_hd__decap_6
XFILLER_0_4_113 VGND VGND VPWR VPWR sky130_fd_sc_hd__fill_1
XFILLER_0_1_105 VGND VGND VPWR VPWR sky130_fd_sc_hd__decap_6
X_484_ clknet_1_0__leaf_clk _005_ net39 VGND VGND VPWR VPWR net29 sky130_fd_sc_hd__dfrtp_1
XFILLER_0_1_149 VPWR VGND VPWR VGND sky130_ef_sc_hd__decap_12
X_467_ _195_ _189_ _227_ _183_ VGND VGND VPWR VPWR _007_ sky130_fd_sc_hd__a31o_1
X_398_ _116_ _119_ _120_ VGND VGND VPWR VPWR _121_ sky130_fd_sc_hd__o21bai_1
X_321_ _042_ _043_ VGND VGND VPWR VPWR _044_ sky130_fd_sc_hd__nand2_1
X_252_ _200_ _199_ VGND VGND VPWR VPWR _202_ sky130_fd_sc_hd__nand2_1
XFILLER_0_10_27 VGND VGND VPWR VPWR sky130_fd_sc_hd__fill_1
XFILLER_0_27_144 VPWR VGND VPWR VGND sky130_ef_sc_hd__decap_12
XFILLER_0_21_48 VGND VGND VPWR VPWR sky130_fd_sc_hd__fill_2
X_304_ _024_ _025_ _233_ VGND VGND VPWR VPWR _027_ sky130_fd_sc_hd__a21o_1
XFILLER_0_15_169 VGND VGND VPWR VPWR sky130_fd_sc_hd__fill_2
XFILLER_0_1_69 VPWR VGND VPWR VGND sky130_ef_sc_hd__decap_12
XFILLER_0_11_81 VGND VGND VPWR VPWR sky130_fd_sc_hd__fill_1
XFILLER_0_21_128 VGND VGND VPWR VPWR sky130_fd_sc_hd__decap_4
XFILLER_0_16_15 VGND VGND VPWR VPWR sky130_fd_sc_hd__decap_4
XFILLER_0_12_139 VGND VGND VPWR VPWR sky130_fd_sc_hd__fill_1
Xoutput28 net28 VGND VGND VPWR VPWR is_outlier sky130_fd_sc_hd__clkbuf_4
XTAP_109 VGND VPWR sky130_fd_sc_hd__tapvpwrvgnd_1
XFILLER_0_16_3 VPWR VGND VPWR VGND sky130_ef_sc_hd__decap_12
XPHY_3 VGND VGND VPWR VPWR sky130_fd_sc_hd__decap_3
X_483_ clknet_1_1__leaf_clk _004_ net39 VGND VGND VPWR VPWR net27 sky130_fd_sc_hd__dfrtp_1
XFILLER_0_7_6 VGND VGND VPWR VPWR sky130_fd_sc_hd__decap_8
XFILLER_0_0_161 VGND VGND VPWR VPWR sky130_fd_sc_hd__fill_1
XFILLER_0_24_37 VGND VGND VPWR VPWR sky130_fd_sc_hd__fill_2
XFILLER_0_5_3 VGND VGND VPWR VPWR sky130_fd_sc_hd__decap_3
X_466_ _191_ net49 VGND VGND VPWR VPWR _183_ sky130_fd_sc_hd__and2_1
X_397_ _107_ _113_ _115_ VGND VGND VPWR VPWR _120_ sky130_fd_sc_hd__and3_1
XFILLER_0_19_48 VGND VGND VPWR VPWR sky130_fd_sc_hd__fill_1
X_320_ _039_ _041_ VGND VGND VPWR VPWR _043_ sky130_fd_sc_hd__or2_1
X_251_ _192_ _199_ _200_ VGND VGND VPWR VPWR _201_ sky130_fd_sc_hd__or3b_2
XFILLER_0_27_156 VGND VGND VPWR VPWR sky130_fd_sc_hd__decap_8
X_449_ _147_ _148_ _145_ VGND VGND VPWR VPWR _172_ sky130_fd_sc_hd__a21oi_1
X_303_ _233_ _024_ _025_ VGND VGND VPWR VPWR _026_ sky130_fd_sc_hd__nand3_1
XFILLER_0_15_137 VPWR VGND VPWR VGND sky130_ef_sc_hd__decap_12
XFILLER_0_12_107 VGND VGND VPWR VPWR sky130_fd_sc_hd__decap_8
XFILLER_0_22_81 VGND VGND VPWR VPWR sky130_fd_sc_hd__decap_3
Xoutput29 net29 VGND VGND VPWR VPWR sideband_out[0] sky130_fd_sc_hd__clkbuf_4
XFILLER_0_7_167 VGND VGND VPWR VPWR sky130_fd_sc_hd__fill_1
XFILLER_0_27_15 VPWR VGND VPWR VGND sky130_ef_sc_hd__decap_12
XPHY_4 VGND VGND VPWR VPWR sky130_fd_sc_hd__decap_3
XFILLER_0_7_47 VGND VGND VPWR VPWR sky130_fd_sc_hd__fill_1
X_482_ clknet_1_1__leaf_clk _003_ net39 VGND VGND VPWR VPWR net26 sky130_fd_sc_hd__dfrtp_1
X_465_ _196_ _189_ _227_ _182_ VGND VGND VPWR VPWR _006_ sky130_fd_sc_hd__a31o_1
X_396_ _117_ _118_ VGND VGND VPWR VPWR _119_ sky130_fd_sc_hd__nand2_1
X_250_ net8 VGND VGND VPWR VPWR _200_ sky130_fd_sc_hd__buf_2
XFILLER_0_10_29 VGND VGND VPWR VPWR sky130_fd_sc_hd__fill_2
X_448_ _160_ _166_ _170_ _158_ _049_ VGND VGND VPWR VPWR _171_ sky130_fd_sc_hd__o311ai_4
X_379_ _231_ net12 _196_ _197_ VGND VGND VPWR VPWR _102_ sky130_fd_sc_hd__and4_1
XFILLER_0_18_124 VPWR VGND VPWR VGND sky130_ef_sc_hd__decap_12
XFILLER_0_5_80 VGND VGND VPWR VPWR sky130_fd_sc_hd__decap_3
X_302_ _020_ net7 _193_ net14 VGND VGND VPWR VPWR _025_ sky130_fd_sc_hd__a22o_1
XFILLER_0_15_149 VPWR VGND VPWR VGND sky130_ef_sc_hd__decap_12
XFILLER_0_20_141 VPWR VGND VPWR VGND sky130_ef_sc_hd__decap_12
XFILLER_0_7_124 VGND VGND VPWR VPWR sky130_fd_sc_hd__fill_1
XFILLER_0_27_27 VPWR VGND VPWR VGND sky130_ef_sc_hd__decap_12
XPHY_5 VGND VGND VPWR VPWR sky130_fd_sc_hd__decap_3
X_481_ clknet_1_1__leaf_clk _002_ net39 VGND VGND VPWR VPWR net25 sky130_fd_sc_hd__dfrtp_1
XFILLER_0_0_130 VGND VGND VPWR VPWR sky130_fd_sc_hd__decap_8
XFILLER_0_8_80 VGND VGND VPWR VPWR sky130_fd_sc_hd__decap_4
X_464_ _191_ net48 VGND VGND VPWR VPWR _182_ sky130_fd_sc_hd__and2_1
X_395_ _016_ _030_ _196_ _197_ VGND VGND VPWR VPWR _118_ sky130_fd_sc_hd__and4_1
XFILLER_0_27_169 VGND VGND VPWR VPWR sky130_fd_sc_hd__fill_2
X_447_ _152_ _167_ _140_ VGND VGND VPWR VPWR _170_ sky130_fd_sc_hd__or3b_2
X_378_ _016_ _195_ _085_ _086_ VGND VGND VPWR VPWR _101_ sky130_fd_sc_hd__nand4_1
XFILLER_0_25_93 VGND VGND VPWR VPWR sky130_fd_sc_hd__fill_2
XFILLER_0_18_136 VGND VGND VPWR VPWR sky130_fd_sc_hd__decap_4
XFILLER_0_24_128 VPWR VGND VPWR VGND sky130_ef_sc_hd__decap_12
XFILLER_0_21_29 VGND VGND VPWR VPWR sky130_fd_sc_hd__fill_1
X_301_ _230_ _020_ _192_ _193_ VGND VGND VPWR VPWR _024_ sky130_fd_sc_hd__nand4_2
XFILLER_0_5_70 VGND VGND VPWR VPWR sky130_fd_sc_hd__fill_1
XFILLER_0_16_29 VGND VGND VPWR VPWR sky130_fd_sc_hd__decap_3
XFILLER_0_20_153 VPWR VGND VPWR VGND sky130_ef_sc_hd__decap_12
XFILLER_0_7_169 VGND VGND VPWR VPWR sky130_fd_sc_hd__fill_2
XFILLER_0_11_131 VPWR VGND VPWR VGND sky130_ef_sc_hd__decap_12
XFILLER_0_27_39 VPWR VGND VPWR VGND sky130_ef_sc_hd__decap_12
XPHY_6 VGND VGND VPWR VPWR sky130_fd_sc_hd__decap_3
XFILLER_0_17_94 VGND VGND VPWR VPWR sky130_fd_sc_hd__fill_2
XFILLER_0_3_150 VPWR VGND VPWR VGND sky130_ef_sc_hd__decap_12
X_480_ clknet_1_1__leaf_clk _001_ net39 VGND VGND VPWR VPWR net24 sky130_fd_sc_hd__dfrtp_1
XFILLER_0_28_93 VGND VGND VPWR VPWR sky130_fd_sc_hd__decap_8
XFILLER_0_14_3 VGND VGND VPWR VPWR sky130_fd_sc_hd__fill_2
XFILLER_0_24_29 VGND VGND VPWR VPWR sky130_fd_sc_hd__decap_8
X_463_ _197_ _189_ _227_ _181_ VGND VGND VPWR VPWR _005_ sky130_fd_sc_hd__a31o_1
X_394_ _231_ _195_ VGND VGND VPWR VPWR _117_ sky130_fd_sc_hd__xnor2_1
X_446_ _049_ _160_ _166_ _168_ VGND VGND VPWR VPWR _169_ sky130_fd_sc_hd__o211ai_2
X_377_ _098_ _099_ VGND VGND VPWR VPWR _100_ sky130_fd_sc_hd__nor2_1
XFILLER_0_3_3 VPWR VGND VPWR VGND sky130_ef_sc_hd__decap_12
X_300_ _019_ _022_ VGND VGND VPWR VPWR _023_ sky130_fd_sc_hd__and2_1
XFILLER_0_5_93 VGND VGND VPWR VPWR sky130_fd_sc_hd__decap_4
X_429_ _141_ _142_ _143_ _151_ VGND VGND VPWR VPWR _152_ sky130_fd_sc_hd__nor4_1
XFILLER_0_11_96 VPWR VGND VPWR VGND sky130_ef_sc_hd__decap_12
Xinput1 data_in[0] VGND VGND VPWR VPWR net1 sky130_fd_sc_hd__buf_1
XTAP_90 VGND VPWR sky130_fd_sc_hd__tapvpwrvgnd_1
XFILLER_0_20_165 VGND VGND VPWR VPWR sky130_fd_sc_hd__decap_6
XFILLER_0_2_83 VGND VGND VPWR VPWR sky130_fd_sc_hd__fill_1
XFILLER_0_7_104 VGND VGND VPWR VPWR sky130_fd_sc_hd__fill_1
XFILLER_0_11_143 VPWR VGND VPWR VGND sky130_ef_sc_hd__decap_12
XPHY_7 VGND VGND VPWR VPWR sky130_fd_sc_hd__decap_3
XFILLER_0_7_39 VGND VGND VPWR VPWR sky130_fd_sc_hd__fill_1
XFILLER_0_3_162 VGND VGND VPWR VPWR sky130_fd_sc_hd__decap_6
XFILLER_0_28_83 VGND VGND VPWR VPWR sky130_fd_sc_hd__fill_1
XFILLER_0_28_72 VGND VGND VPWR VPWR sky130_fd_sc_hd__decap_4
XFILLER_0_8_93 VGND VGND VPWR VPWR sky130_fd_sc_hd__fill_2
X_462_ _191_ net46 VGND VGND VPWR VPWR _181_ sky130_fd_sc_hd__and2_1
X_393_ _107_ _113_ _115_ VGND VGND VPWR VPWR _116_ sky130_fd_sc_hd__a21oi_1
X_445_ _167_ _152_ _140_ VGND VGND VPWR VPWR _168_ sky130_fd_sc_hd__mux2_1
XFILLER_0_18_105 VGND VGND VPWR VPWR sky130_fd_sc_hd__decap_8
X_376_ _096_ _097_ _090_ VGND VGND VPWR VPWR _099_ sky130_fd_sc_hd__a21oi_1
XFILLER_0_5_50 VGND VGND VPWR VPWR sky130_fd_sc_hd__fill_1
X_428_ _149_ _150_ VGND VGND VPWR VPWR _151_ sky130_fd_sc_hd__nand2_2
XFILLER_0_1_19 VPWR VGND VPWR VGND sky130_ef_sc_hd__decap_12
XFILLER_0_11_42 VPWR VGND VPWR VGND sky130_ef_sc_hd__decap_12
XFILLER_0_11_75 VGND VGND VPWR VPWR sky130_fd_sc_hd__decap_6
X_359_ _079_ _080_ _081_ VGND VGND VPWR VPWR _082_ sky130_fd_sc_hd__nand3_1
Xinput2 data_in[1] VGND VGND VPWR VPWR net2 sky130_fd_sc_hd__dlymetal6s2s_1
XFILLER_0_14_141 VPWR VGND VPWR VGND sky130_ef_sc_hd__decap_12
XTAP_80 VGND VPWR sky130_fd_sc_hd__tapvpwrvgnd_1
XTAP_91 VGND VPWR sky130_fd_sc_hd__tapvpwrvgnd_1
XFILLER_0_22_63 VGND VGND VPWR VPWR sky130_fd_sc_hd__fill_2
XFILLER_0_22_41 VPWR VGND VPWR VGND sky130_ef_sc_hd__decap_12
XFILLER_0_11_155 VPWR VGND VPWR VGND sky130_ef_sc_hd__decap_12
XFILLER_0_23_9 VGND VGND VPWR VPWR sky130_fd_sc_hd__fill_1
XPHY_8 VGND VGND VPWR VPWR sky130_fd_sc_hd__decap_3
XFILLER_0_28_62 VGND VGND VPWR VPWR sky130_fd_sc_hd__decap_3
XFILLER_0_0_155 VGND VGND VPWR VPWR sky130_fd_sc_hd__fill_2
XFILLER_0_8_61 VGND VGND VPWR VPWR sky130_fd_sc_hd__fill_2
X_461_ _191_ net42 _228_ _180_ VGND VGND VPWR VPWR _004_ sky130_fd_sc_hd__a22o_1
X_392_ _102_ _114_ _030_ _195_ VGND VGND VPWR VPWR _115_ sky130_fd_sc_hd__and4b_1
XFILLER_0_14_42 VGND VGND VPWR VPWR sky130_fd_sc_hd__decap_3
X_444_ _141_ _142_ _151_ _143_ VGND VGND VPWR VPWR _167_ sky130_fd_sc_hd__o31a_1
XFILLER_0_25_63 VPWR VGND VPWR VGND sky130_ef_sc_hd__decap_12
X_375_ _090_ _096_ _097_ VGND VGND VPWR VPWR _098_ sky130_fd_sc_hd__and3_2
X_427_ _100_ _123_ VGND VGND VPWR VPWR _150_ sky130_fd_sc_hd__xor2_1
XFILLER_0_17_161 VGND VGND VPWR VPWR sky130_fd_sc_hd__decap_3
X_358_ net12 net4 VGND VGND VPWR VPWR _081_ sky130_fd_sc_hd__and2_1
Xinput3 data_in[2] VGND VGND VPWR VPWR net3 sky130_fd_sc_hd__clkbuf_2
X_289_ _230_ _231_ net8 VGND VGND VPWR VPWR _238_ sky130_fd_sc_hd__o21ai_1
XTAP_70 VGND VPWR sky130_fd_sc_hd__tapvpwrvgnd_1
XTAP_81 VGND VPWR sky130_fd_sc_hd__tapvpwrvgnd_1
XTAP_92 VGND VPWR sky130_fd_sc_hd__tapvpwrvgnd_1
XFILLER_0_11_54 VGND VGND VPWR VPWR sky130_fd_sc_hd__fill_2
XFILLER_0_11_65 VGND VGND VPWR VPWR sky130_fd_sc_hd__decap_6
XFILLER_0_20_101 VGND VGND VPWR VPWR sky130_fd_sc_hd__decap_6
XFILLER_0_14_153 VPWR VGND VPWR VGND sky130_ef_sc_hd__decap_12
XFILLER_0_22_53 VGND VGND VPWR VPWR sky130_fd_sc_hd__fill_2
XFILLER_0_7_139 VPWR VGND VPWR VGND sky130_ef_sc_hd__decap_12
XFILLER_0_11_167 VGND VGND VPWR VPWR sky130_fd_sc_hd__fill_1
XFILLER_0_2_85 VPWR VGND VPWR VGND sky130_ef_sc_hd__decap_12
XFILLER_0_2_41 VPWR VGND VPWR VGND sky130_ef_sc_hd__decap_12
XFILLER_0_4_109 VGND VGND VPWR VPWR sky130_fd_sc_hd__decap_4
XPHY_9 VGND VGND VPWR VPWR sky130_fd_sc_hd__decap_3
XFILLER_0_17_86 VGND VGND VPWR VPWR sky130_fd_sc_hd__decap_8
XFILLER_0_28_85 VGND VGND VPWR VPWR sky130_fd_sc_hd__fill_2
X_460_ _159_ VGND VGND VPWR VPWR _180_ sky130_fd_sc_hd__inv_2
X_391_ _016_ _196_ _197_ _231_ VGND VGND VPWR VPWR _114_ sky130_fd_sc_hd__a22o_1
XFILLER_0_14_65 VGND VGND VPWR VPWR sky130_fd_sc_hd__decap_8
XFILLER_0_12_3 VPWR VGND VPWR VGND sky130_ef_sc_hd__decap_12
X_443_ _142_ _165_ VGND VGND VPWR VPWR _166_ sky130_fd_sc_hd__xnor2_2
X_374_ _030_ _193_ _094_ _095_ VGND VGND VPWR VPWR _097_ sky130_fd_sc_hd__a22o_1
XFILLER_0_25_75 VPWR VGND VPWR VGND sky130_ef_sc_hd__decap_12
Xinput4 data_in[3] VGND VGND VPWR VPWR net4 sky130_fd_sc_hd__clkbuf_4
X_426_ _145_ _147_ _148_ VGND VGND VPWR VPWR _149_ sky130_fd_sc_hd__and3_1
X_288_ _230_ net8 _231_ VGND VGND VPWR VPWR _237_ sky130_fd_sc_hd__and3_1
XTAP_60 VGND VPWR sky130_fd_sc_hd__tapvpwrvgnd_1
XTAP_71 VGND VPWR sky130_fd_sc_hd__tapvpwrvgnd_1
XTAP_82 VGND VPWR sky130_fd_sc_hd__tapvpwrvgnd_1
X_357_ _230_ _020_ _195_ _196_ VGND VGND VPWR VPWR _080_ sky130_fd_sc_hd__nand4_1
XTAP_93 VGND VPWR sky130_fd_sc_hd__tapvpwrvgnd_1
X_409_ _058_ _076_ _075_ VGND VGND VPWR VPWR _132_ sky130_fd_sc_hd__a21oi_1
XFILLER_0_7_118 VGND VGND VPWR VPWR sky130_fd_sc_hd__decap_6
XFILLER_0_2_97 VPWR VGND VPWR VGND sky130_ef_sc_hd__decap_12
XFILLER_0_2_53 VPWR VGND VPWR VGND sky130_ef_sc_hd__decap_12
XFILLER_0_17_76 VGND VGND VPWR VPWR sky130_fd_sc_hd__decap_3
XFILLER_0_17_43 VGND VGND VPWR VPWR sky130_fd_sc_hd__decap_3
XFILLER_0_3_121 VGND VGND VPWR VPWR sky130_fd_sc_hd__decap_3
XFILLER_0_28_20 VGND VGND VPWR VPWR sky130_fd_sc_hd__decap_8
XFILLER_0_0_113 VGND VGND VPWR VPWR sky130_fd_sc_hd__fill_2
XFILLER_0_8_85 VGND VGND VPWR VPWR sky130_fd_sc_hd__decap_8
X_390_ _104_ _106_ _105_ VGND VGND VPWR VPWR _113_ sky130_fd_sc_hd__o21ai_1
X_442_ _151_ _162_ _163_ _164_ VGND VGND VPWR VPWR _165_ sky130_fd_sc_hd__o211a_1
X_373_ _030_ _193_ _094_ _095_ VGND VGND VPWR VPWR _096_ sky130_fd_sc_hd__nand4_1
XFILLER_0_26_141 VPWR VGND VPWR VGND sky130_ef_sc_hd__decap_12
XFILLER_0_25_98 VPWR VGND VPWR VGND sky130_ef_sc_hd__decap_12
XFILLER_0_25_87 VGND VGND VPWR VPWR sky130_fd_sc_hd__fill_1
Xinput5 data_in[4] VGND VGND VPWR VPWR net5 sky130_fd_sc_hd__buf_1
XFILLER_0_23_166 VGND VGND VPWR VPWR sky130_fd_sc_hd__fill_2
X_287_ _233_ _234_ _235_ VGND VGND VPWR VPWR _236_ sky130_fd_sc_hd__and3_1
X_356_ _020_ net3 net2 net14 VGND VGND VPWR VPWR _079_ sky130_fd_sc_hd__a22o_1
XFILLER_0_11_89 VGND VGND VPWR VPWR sky130_fd_sc_hd__fill_2
X_425_ _146_ _119_ net9 VGND VGND VPWR VPWR _148_ sky130_fd_sc_hd__o21a_1
XTAP_61 VGND VPWR sky130_fd_sc_hd__tapvpwrvgnd_1
XTAP_72 VGND VPWR sky130_fd_sc_hd__tapvpwrvgnd_1
XTAP_83 VGND VPWR sky130_fd_sc_hd__tapvpwrvgnd_1
XTAP_94 VGND VPWR sky130_fd_sc_hd__tapvpwrvgnd_1
X_408_ _098_ _130_ VGND VGND VPWR VPWR _131_ sky130_fd_sc_hd__xor2_2
XFILLER_0_22_99 VGND VGND VPWR VPWR sky130_fd_sc_hd__decap_8
X_339_ _038_ _061_ VGND VGND VPWR VPWR _062_ sky130_fd_sc_hd__and2_1
XFILLER_0_2_65 VPWR VGND VPWR VGND sky130_ef_sc_hd__decap_12
XFILLER_0_6_141 VPWR VGND VPWR VGND sky130_ef_sc_hd__decap_12
XFILLER_0_11_169 VGND VGND VPWR VPWR sky130_fd_sc_hd__fill_2
XFILLER_0_3_111 VGND VGND VPWR VPWR sky130_fd_sc_hd__fill_1
XFILLER_0_28_76 VGND VGND VPWR VPWR sky130_fd_sc_hd__fill_1
XFILLER_0_0_169 VGND VGND VPWR VPWR sky130_fd_sc_hd__fill_2
XFILLER_0_0_147 VGND VGND VPWR VPWR sky130_fd_sc_hd__decap_8
XFILLER_0_14_34 VGND VGND VPWR VPWR sky130_fd_sc_hd__decap_8
X_441_ _098_ _130_ VGND VGND VPWR VPWR _164_ sky130_fd_sc_hd__nand2_1
X_372_ _091_ _093_ _092_ VGND VGND VPWR VPWR _095_ sky130_fd_sc_hd__a21o_1
XFILLER_0_26_153 VPWR VGND VPWR VGND sky130_ef_sc_hd__decap_12
X_355_ _065_ _077_ VGND VGND VPWR VPWR _078_ sky130_fd_sc_hd__xnor2_2
XFILLER_0_23_134 VPWR VGND VPWR VGND sky130_ef_sc_hd__decap_12
X_424_ _146_ _119_ VGND VGND VPWR VPWR _147_ sky130_fd_sc_hd__nand2_1
XFILLER_0_11_13 VPWR VGND VPWR VGND sky130_ef_sc_hd__decap_12
XFILLER_0_11_57 VGND VGND VPWR VPWR sky130_fd_sc_hd__fill_2
X_286_ _230_ net8 _231_ _192_ VGND VGND VPWR VPWR _235_ sky130_fd_sc_hd__nand4_1
Xinput6 data_in[5] VGND VGND VPWR VPWR net6 sky130_fd_sc_hd__clkbuf_1
XTAP_62 VGND VPWR sky130_fd_sc_hd__tapvpwrvgnd_1
XTAP_73 VGND VPWR sky130_fd_sc_hd__tapvpwrvgnd_1
XTAP_84 VGND VPWR sky130_fd_sc_hd__tapvpwrvgnd_1
XTAP_95 VGND VPWR sky130_fd_sc_hd__tapvpwrvgnd_1
X_407_ _128_ _129_ VGND VGND VPWR VPWR _130_ sky130_fd_sc_hd__nor2b_2
X_338_ _037_ _029_ _032_ VGND VGND VPWR VPWR _061_ sky130_fd_sc_hd__or3_1
XFILLER_0_2_77 VGND VGND VPWR VPWR sky130_fd_sc_hd__decap_6
X_269_ net16 _217_ net15 _218_ VGND VGND VPWR VPWR _219_ sky130_fd_sc_hd__a211o_1
XFILLER_0_6_153 VPWR VGND VPWR VGND sky130_ef_sc_hd__decap_12
Xinput20 threshold[5] VGND VGND VPWR VPWR net20 sky130_fd_sc_hd__buf_1
XFILLER_0_28_44 VPWR VGND VPWR VGND sky130_ef_sc_hd__decap_12
X_440_ _161_ _130_ VGND VGND VPWR VPWR _163_ sky130_fd_sc_hd__nand2_1
Xfanout39 net10 VGND VGND VPWR VPWR net39 sky130_fd_sc_hd__buf_4
X_371_ _091_ _092_ _093_ VGND VGND VPWR VPWR _094_ sky130_fd_sc_hd__nand3_1
XFILLER_0_26_165 VGND VGND VPWR VPWR sky130_fd_sc_hd__decap_6
XFILLER_0_10_3 VPWR VGND VPWR VGND sky130_ef_sc_hd__decap_12
X_354_ _058_ _075_ _076_ VGND VGND VPWR VPWR _077_ sky130_fd_sc_hd__and3_2
XFILLER_0_23_146 VPWR VGND VPWR VGND sky130_ef_sc_hd__decap_12
X_285_ net8 _231_ _192_ _230_ VGND VGND VPWR VPWR _234_ sky130_fd_sc_hd__a22o_1
X_423_ _120_ _116_ VGND VGND VPWR VPWR _146_ sky130_fd_sc_hd__or2_1
XFILLER_0_11_25 VGND VGND VPWR VPWR sky130_fd_sc_hd__decap_4
XTAP_63 VGND VPWR sky130_fd_sc_hd__tapvpwrvgnd_1
Xinput7 data_in[6] VGND VGND VPWR VPWR net7 sky130_fd_sc_hd__buf_1
XTAP_74 VGND VPWR sky130_fd_sc_hd__tapvpwrvgnd_1
XTAP_85 VGND VPWR sky130_fd_sc_hd__tapvpwrvgnd_1
XTAP_96 VGND VPWR sky130_fd_sc_hd__tapvpwrvgnd_1
X_406_ _124_ _127_ _126_ VGND VGND VPWR VPWR _129_ sky130_fd_sc_hd__a21o_1
X_337_ _055_ _058_ _059_ VGND VGND VPWR VPWR _060_ sky130_fd_sc_hd__a21boi_2
X_268_ _197_ VGND VGND VPWR VPWR _218_ sky130_fd_sc_hd__inv_2
XFILLER_0_6_165 VGND VGND VPWR VPWR sky130_fd_sc_hd__decap_3
XFILLER_0_17_68 VGND VGND VPWR VPWR sky130_fd_sc_hd__decap_8
XFILLER_0_17_57 VGND VGND VPWR VPWR sky130_fd_sc_hd__decap_8
XFILLER_0_17_35 VGND VGND VPWR VPWR sky130_fd_sc_hd__decap_8
Xinput10 rst_n VGND VGND VPWR VPWR net10 sky130_fd_sc_hd__clkbuf_2
Xinput21 threshold[6] VGND VGND VPWR VPWR net21 sky130_fd_sc_hd__buf_1
XFILLER_0_3_113 VGND VGND VPWR VPWR sky130_fd_sc_hd__decap_8
XFILLER_0_0_138 VGND VGND VPWR VPWR sky130_fd_sc_hd__fill_2
XFILLER_0_14_25 VGND VGND VPWR VPWR sky130_fd_sc_hd__decap_3
XFILLER_0_20_90 VGND VGND VPWR VPWR sky130_fd_sc_hd__decap_4
XFILLER_0_25_57 VGND VGND VPWR VPWR sky130_fd_sc_hd__fill_1
X_370_ _071_ _070_ _069_ VGND VGND VPWR VPWR _093_ sky130_fd_sc_hd__a21o_1
XFILLER_0_26_100 VGND VGND VPWR VPWR sky130_fd_sc_hd__fill_2
X_353_ _055_ _057_ _229_ VGND VGND VPWR VPWR _076_ sky130_fd_sc_hd__a21bo_1
X_284_ net8 net12 VGND VGND VPWR VPWR _233_ sky130_fd_sc_hd__and2_1
X_422_ _144_ _121_ VGND VGND VPWR VPWR _145_ sky130_fd_sc_hd__xnor2_1
XFILLER_0_1_7 VPWR VGND VPWR VGND sky130_ef_sc_hd__decap_12
XFILLER_0_23_169 VGND VGND VPWR VPWR sky130_fd_sc_hd__fill_2
XFILLER_0_23_158 VGND VGND VPWR VPWR sky130_fd_sc_hd__decap_8
XFILLER_0_14_114 VGND VGND VPWR VPWR sky130_fd_sc_hd__decap_3
Xinput8 data_in[7] VGND VGND VPWR VPWR net8 sky130_fd_sc_hd__buf_2
XTAP_64 VGND VPWR sky130_fd_sc_hd__tapvpwrvgnd_1
XTAP_75 VGND VPWR sky130_fd_sc_hd__tapvpwrvgnd_1
XTAP_86 VGND VPWR sky130_fd_sc_hd__tapvpwrvgnd_1
XTAP_97 VGND VPWR sky130_fd_sc_hd__tapvpwrvgnd_1
X_405_ _124_ _126_ _127_ VGND VGND VPWR VPWR _128_ sky130_fd_sc_hd__and3_2
X_336_ _229_ _031_ VGND VGND VPWR VPWR _059_ sky130_fd_sc_hd__xnor2_1
X_267_ _196_ _216_ VGND VGND VPWR VPWR _217_ sky130_fd_sc_hd__xor2_1
Xinput11 scale[0] VGND VGND VPWR VPWR net11 sky130_fd_sc_hd__dlymetal6s2s_1
X_319_ _039_ _041_ VGND VGND VPWR VPWR _042_ sky130_fd_sc_hd__nand2_1
XFILLER_0_3_169 VGND VGND VPWR VPWR sky130_fd_sc_hd__fill_2
Xclkbuf_1_0__f_clk clknet_0_clk VGND VGND VPWR VPWR clknet_1_0__leaf_clk sky130_fd_sc_hd__clkbuf_16
Xinput22 threshold[7] VGND VGND VPWR VPWR net22 sky130_fd_sc_hd__dlymetal6s2s_1
XFILLER_0_28_57 VGND VGND VPWR VPWR sky130_fd_sc_hd__fill_2
XFILLER_0_25_47 VGND VGND VPWR VPWR sky130_fd_sc_hd__decap_3
XFILLER_0_5_57 VGND VGND VPWR VPWR sky130_fd_sc_hd__decap_3
X_421_ _108_ _111_ VGND VGND VPWR VPWR _144_ sky130_fd_sc_hd__xnor2_1
X_352_ _066_ _073_ _074_ VGND VGND VPWR VPWR _075_ sky130_fd_sc_hd__o21bai_1
X_283_ _230_ net8 _231_ _192_ VGND VGND VPWR VPWR _232_ sky130_fd_sc_hd__and4_1
Xinput9 round_mode VGND VGND VPWR VPWR net9 sky130_fd_sc_hd__buf_1
XTAP_65 VGND VPWR sky130_fd_sc_hd__tapvpwrvgnd_1
XTAP_76 VGND VPWR sky130_fd_sc_hd__tapvpwrvgnd_1
XTAP_87 VGND VPWR sky130_fd_sc_hd__tapvpwrvgnd_1
XTAP_98 VGND VPWR sky130_fd_sc_hd__tapvpwrvgnd_1
X_404_ _074_ _073_ _066_ VGND VGND VPWR VPWR _127_ sky130_fd_sc_hd__o21ai_1
X_335_ _229_ _056_ _057_ VGND VGND VPWR VPWR _058_ sky130_fd_sc_hd__or3b_2
X_266_ net8 _197_ VGND VGND VPWR VPWR _216_ sky130_fd_sc_hd__nand2_1
XFILLER_0_6_112 VGND VGND VPWR VPWR sky130_fd_sc_hd__decap_3
Xmax_cap38 _152_ VGND VGND VPWR VPWR net38 sky130_fd_sc_hd__buf_1
Xinput23 valid_in VGND VGND VPWR VPWR net23 sky130_fd_sc_hd__buf_1
X_318_ _229_ _040_ VGND VGND VPWR VPWR _041_ sky130_fd_sc_hd__xor2_1
XFILLER_0_17_15 VPWR VGND VPWR VGND sky130_ef_sc_hd__decap_12
Xinput12 scale[1] VGND VGND VPWR VPWR net12 sky130_fd_sc_hd__clkbuf_2
X_249_ _193_ _194_ _198_ VGND VGND VPWR VPWR _199_ sky130_fd_sc_hd__or3_1
XFILLER_0_0_118 VPWR VGND VPWR VGND sky130_ef_sc_hd__decap_12
XFILLER_0_8_68 VPWR VGND VPWR VGND sky130_ef_sc_hd__decap_12
Xhold1 net24 VGND VGND VPWR VPWR net40 sky130_fd_sc_hd__dlygate4sd3_1
XFILLER_0_25_15 VPWR VGND VPWR VGND sky130_ef_sc_hd__decap_12
X_420_ _078_ _137_ VGND VGND VPWR VPWR _143_ sky130_fd_sc_hd__xnor2_1
X_351_ _067_ _072_ _068_ VGND VGND VPWR VPWR _074_ sky130_fd_sc_hd__and3_1
X_282_ net13 VGND VGND VPWR VPWR _231_ sky130_fd_sc_hd__clkbuf_4
XTAP_99 VGND VPWR sky130_fd_sc_hd__tapvpwrvgnd_1
XTAP_66 VGND VPWR sky130_fd_sc_hd__tapvpwrvgnd_1
XTAP_77 VGND VPWR sky130_fd_sc_hd__tapvpwrvgnd_1
XTAP_88 VGND VPWR sky130_fd_sc_hd__tapvpwrvgnd_1
XPHY_50 VGND VGND VPWR VPWR sky130_fd_sc_hd__decap_3
X_334_ _022_ _054_ _053_ VGND VGND VPWR VPWR _057_ sky130_fd_sc_hd__a21o_1
X_403_ _030_ _193_ _095_ _125_ VGND VGND VPWR VPWR _126_ sky130_fd_sc_hd__a31o_1
XFILLER_0_9_165 VGND VGND VPWR VPWR sky130_fd_sc_hd__decap_3
XFILLER_0_2_15 VPWR VGND VPWR VGND sky130_ef_sc_hd__decap_12
X_265_ net17 _214_ VGND VGND VPWR VPWR _215_ sky130_fd_sc_hd__or2_1
XFILLER_0_6_135 VGND VGND VPWR VPWR sky130_fd_sc_hd__decap_4
XFILLER_0_11_108 VGND VGND VPWR VPWR sky130_fd_sc_hd__decap_4
XFILLER_0_10_141 VPWR VGND VPWR VGND sky130_ef_sc_hd__decap_12
Xinput13 scale[2] VGND VGND VPWR VPWR net13 sky130_fd_sc_hd__buf_1
X_317_ _016_ _237_ _015_ VGND VGND VPWR VPWR _040_ sky130_fd_sc_hd__a21bo_1
XFILLER_0_3_138 VPWR VGND VPWR VGND sky130_ef_sc_hd__decap_12
X_248_ net4 _195_ _196_ _197_ VGND VGND VPWR VPWR _198_ sky130_fd_sc_hd__or4_1
XFILLER_0_23_81 VGND VGND VPWR VPWR sky130_fd_sc_hd__decap_3
XFILLER_0_28_37 VGND VGND VPWR VPWR sky130_fd_sc_hd__fill_1
XFILLER_0_18_81 VGND VGND VPWR VPWR sky130_fd_sc_hd__decap_3
Xhold2 net28 VGND VGND VPWR VPWR net41 sky130_fd_sc_hd__dlygate4sd3_1
XFILLER_0_26_114 VPWR VGND VPWR VGND sky130_ef_sc_hd__decap_12
XFILLER_0_25_27 VPWR VGND VPWR VGND sky130_ef_sc_hd__decap_12
XFILLER_0_8_3 VPWR VGND VPWR VGND sky130_ef_sc_hd__decap_12
XFILLER_0_17_169 VGND VGND VPWR VPWR sky130_fd_sc_hd__fill_2
XFILLER_0_17_125 VPWR VGND VPWR VGND sky130_ef_sc_hd__decap_12
XFILLER_0_5_26 VGND VGND VPWR VPWR sky130_fd_sc_hd__fill_2
X_350_ _067_ _068_ _072_ VGND VGND VPWR VPWR _073_ sky130_fd_sc_hd__a21oi_1
X_281_ net14 VGND VGND VPWR VPWR _230_ sky130_fd_sc_hd__buf_2
XFILLER_0_11_29 VGND VGND VPWR VPWR sky130_fd_sc_hd__fill_1
X_479_ clknet_1_1__leaf_clk net23 net39 VGND VGND VPWR VPWR net37 sky130_fd_sc_hd__dfrtp_1
XFILLER_0_14_106 VGND VGND VPWR VPWR sky130_fd_sc_hd__decap_8
XTAP_67 VGND VPWR sky130_fd_sc_hd__tapvpwrvgnd_1
XTAP_78 VGND VPWR sky130_fd_sc_hd__tapvpwrvgnd_1
XTAP_89 VGND VPWR sky130_fd_sc_hd__tapvpwrvgnd_1
XFILLER_0_9_111 VGND VGND VPWR VPWR sky130_fd_sc_hd__fill_1
XPHY_51 VGND VGND VPWR VPWR sky130_fd_sc_hd__decap_3
X_333_ _022_ _053_ _054_ VGND VGND VPWR VPWR _056_ sky130_fd_sc_hd__and3_1
XPHY_40 VGND VGND VPWR VPWR sky130_fd_sc_hd__decap_3
X_402_ _091_ _092_ _093_ VGND VGND VPWR VPWR _125_ sky130_fd_sc_hd__and3_1
XFILLER_0_2_27 VGND VGND VPWR VPWR sky130_fd_sc_hd__fill_1
X_264_ _195_ _213_ VGND VGND VPWR VPWR _214_ sky130_fd_sc_hd__xnor2_1
XFILLER_0_10_131 VGND VGND VPWR VPWR sky130_fd_sc_hd__decap_8
XFILLER_0_10_153 VPWR VGND VPWR VGND sky130_ef_sc_hd__decap_12
X_316_ _200_ _030_ _036_ _034_ VGND VGND VPWR VPWR _039_ sky130_fd_sc_hd__a31o_1
Xinput14 scale[3] VGND VGND VPWR VPWR net14 sky130_fd_sc_hd__buf_2
X_247_ net1 VGND VGND VPWR VPWR _197_ sky130_fd_sc_hd__buf_2
XFILLER_0_23_60 VGND VGND VPWR VPWR sky130_fd_sc_hd__decap_8
XFILLER_0_0_109 VGND VGND VPWR VPWR sky130_fd_sc_hd__decap_3
XFILLER_0_8_15 VPWR VGND VPWR VGND sky130_ef_sc_hd__decap_12
XFILLER_0_8_37 VGND VGND VPWR VPWR sky130_fd_sc_hd__fill_2
Xhold3 net27 VGND VGND VPWR VPWR net42 sky130_fd_sc_hd__dlygate4sd3_1
XFILLER_0_26_126 VPWR VGND VPWR VGND sky130_ef_sc_hd__decap_12
XFILLER_0_25_39 VGND VGND VPWR VPWR sky130_fd_sc_hd__decap_8
XFILLER_0_17_137 VPWR VGND VPWR VGND sky130_ef_sc_hd__decap_12
XFILLER_0_17_104 VGND VGND VPWR VPWR sky130_fd_sc_hd__decap_4
XFILLER_0_15_50 VGND VGND VPWR VPWR sky130_fd_sc_hd__decap_6
X_280_ net8 net11 VGND VGND VPWR VPWR _229_ sky130_fd_sc_hd__nand2_2
X_478_ clknet_1_1__leaf_clk _000_ net39 VGND VGND VPWR VPWR net28 sky130_fd_sc_hd__dfrtp_1
XTAP_68 VGND VPWR sky130_fd_sc_hd__tapvpwrvgnd_1
XTAP_79 VGND VPWR sky130_fd_sc_hd__tapvpwrvgnd_1
XFILLER_0_9_145 VPWR VGND VPWR VGND sky130_ef_sc_hd__decap_12
XPHY_52 VGND VGND VPWR VPWR sky130_fd_sc_hd__decap_3
X_401_ _074_ _066_ _073_ VGND VGND VPWR VPWR _124_ sky130_fd_sc_hd__or3_1
XFILLER_0_22_29 VGND VGND VPWR VPWR sky130_fd_sc_hd__fill_1
XPHY_41 VGND VGND VPWR VPWR sky130_fd_sc_hd__decap_3
X_332_ _022_ _053_ _054_ VGND VGND VPWR VPWR _055_ sky130_fd_sc_hd__nand3_1
XPHY_30 VGND VGND VPWR VPWR sky130_fd_sc_hd__decap_3
X_263_ _196_ _197_ _200_ VGND VGND VPWR VPWR _213_ sky130_fd_sc_hd__o21a_1
XFILLER_0_10_165 VGND VGND VPWR VPWR sky130_fd_sc_hd__fill_2
XFILLER_0_28_9 VGND VGND VPWR VPWR sky130_fd_sc_hd__decap_8
X_315_ _029_ _032_ _037_ VGND VGND VPWR VPWR _038_ sky130_fd_sc_hd__o21ai_2
XFILLER_0_3_129 VGND VGND VPWR VPWR sky130_fd_sc_hd__fill_1
Xinput15 threshold[0] VGND VGND VPWR VPWR net15 sky130_fd_sc_hd__buf_1
X_246_ net2 VGND VGND VPWR VPWR _196_ sky130_fd_sc_hd__buf_2
XFILLER_0_8_27 VGND VGND VPWR VPWR sky130_fd_sc_hd__fill_1
XFILLER_0_8_49 VPWR VGND VPWR VGND sky130_ef_sc_hd__decap_12
Xhold4 net25 VGND VGND VPWR VPWR net43 sky130_fd_sc_hd__dlygate4sd3_1
XFILLER_0_24_3 VGND VGND VPWR VPWR sky130_fd_sc_hd__decap_8
XFILLER_0_26_138 VGND VGND VPWR VPWR sky130_fd_sc_hd__fill_2
XFILLER_0_15_84 VGND VGND VPWR VPWR sky130_fd_sc_hd__decap_3
XFILLER_0_15_73 VGND VGND VPWR VPWR sky130_fd_sc_hd__decap_3
XFILLER_0_17_149 VPWR VGND VPWR VGND sky130_ef_sc_hd__decap_12
XTAP_69 VGND VPWR sky130_fd_sc_hd__tapvpwrvgnd_1
XTAP_58 VGND VPWR sky130_fd_sc_hd__tapvpwrvgnd_1
X_477_ _200_ _189_ _227_ _188_ VGND VGND VPWR VPWR _012_ sky130_fd_sc_hd__a31o_1
XFILLER_0_22_141 VPWR VGND VPWR VGND sky130_ef_sc_hd__decap_12
XFILLER_0_13_141 VPWR VGND VPWR VGND sky130_ef_sc_hd__decap_12
XFILLER_0_9_113 VGND VGND VPWR VPWR sky130_fd_sc_hd__decap_4
XFILLER_0_9_157 VGND VGND VPWR VPWR sky130_fd_sc_hd__decap_8
XPHY_53 VGND VGND VPWR VPWR sky130_fd_sc_hd__decap_3
XPHY_42 VGND VGND VPWR VPWR sky130_fd_sc_hd__decap_3
X_331_ _016_ _192_ _019_ _021_ VGND VGND VPWR VPWR _054_ sky130_fd_sc_hd__a22o_1
XPHY_31 VGND VGND VPWR VPWR sky130_fd_sc_hd__decap_3
X_400_ _112_ _121_ _122_ VGND VGND VPWR VPWR _123_ sky130_fd_sc_hd__a21o_1
X_262_ net18 _211_ VGND VGND VPWR VPWR _212_ sky130_fd_sc_hd__or2_1
XPHY_20 VGND VGND VPWR VPWR sky130_fd_sc_hd__decap_3
XFILLER_0_2_29 VPWR VGND VPWR VGND sky130_ef_sc_hd__decap_12
XFILLER_0_12_41 VGND VGND VPWR VPWR sky130_fd_sc_hd__decap_3
XFILLER_0_12_74 VGND VGND VPWR VPWR sky130_fd_sc_hd__fill_2
XFILLER_0_12_85 VGND VGND VPWR VPWR sky130_fd_sc_hd__decap_4
X_314_ _229_ _036_ VGND VGND VPWR VPWR _037_ sky130_fd_sc_hd__xnor2_1
Xinput16 threshold[1] VGND VGND VPWR VPWR net16 sky130_fd_sc_hd__buf_1
X_245_ net3 VGND VGND VPWR VPWR _195_ sky130_fd_sc_hd__clkbuf_4
XFILLER_0_2_141 VPWR VGND VPWR VGND sky130_ef_sc_hd__decap_12
XFILLER_0_28_29 VGND VGND VPWR VPWR sky130_fd_sc_hd__decap_8
Xhold5 net26 VGND VGND VPWR VPWR net44 sky130_fd_sc_hd__dlygate4sd3_1
XFILLER_0_17_3 VPWR VGND VPWR VGND sky130_ef_sc_hd__decap_12
XTAP_59 VGND VPWR sky130_fd_sc_hd__tapvpwrvgnd_1
X_476_ _190_ net45 VGND VGND VPWR VPWR _188_ sky130_fd_sc_hd__and2_1
XFILLER_0_6_3 VGND VGND VPWR VPWR sky130_fd_sc_hd__decap_8
XFILLER_0_26_51 VGND VGND VPWR VPWR sky130_fd_sc_hd__decap_8
XFILLER_0_22_153 VPWR VGND VPWR VGND sky130_ef_sc_hd__decap_12
XFILLER_0_9_169 VGND VGND VPWR VPWR sky130_fd_sc_hd__fill_2
XPHY_54 VGND VGND VPWR VPWR sky130_fd_sc_hd__decap_3
XPHY_43 VGND VGND VPWR VPWR sky130_fd_sc_hd__decap_3
X_330_ _050_ _051_ _052_ VGND VGND VPWR VPWR _053_ sky130_fd_sc_hd__a21bo_1
XPHY_32 VGND VGND VPWR VPWR sky130_fd_sc_hd__decap_3
XFILLER_0_13_153 VPWR VGND VPWR VGND sky130_ef_sc_hd__decap_12
XPHY_10 VGND VGND VPWR VPWR sky130_fd_sc_hd__decap_3
X_261_ net4 _210_ VGND VGND VPWR VPWR _211_ sky130_fd_sc_hd__xnor2_1
XPHY_21 VGND VGND VPWR VPWR sky130_fd_sc_hd__decap_3
X_459_ _191_ net44 _228_ _179_ VGND VGND VPWR VPWR _003_ sky130_fd_sc_hd__a22o_1
XFILLER_0_6_139 VGND VGND VPWR VPWR sky130_fd_sc_hd__fill_1
Xinput17 threshold[2] VGND VGND VPWR VPWR net17 sky130_fd_sc_hd__buf_1
X_244_ net5 VGND VGND VPWR VPWR _194_ sky130_fd_sc_hd__clkbuf_4
X_313_ _034_ _035_ VGND VGND VPWR VPWR _036_ sky130_fd_sc_hd__nor2_1
XFILLER_0_2_153 VPWR VGND VPWR VGND sky130_ef_sc_hd__decap_12
XFILLER_0_18_85 VGND VGND VPWR VPWR sky130_fd_sc_hd__decap_4
XFILLER_0_20_64 VPWR VGND VPWR VGND sky130_ef_sc_hd__decap_12
Xhold6 net36 VGND VGND VPWR VPWR net45 sky130_fd_sc_hd__dlygate4sd3_1
XFILLER_0_0_85 VPWR VGND VPWR VGND sky130_ef_sc_hd__decap_12
Xclkbuf_1_1__f_clk clknet_0_clk VGND VGND VPWR VPWR clknet_1_1__leaf_clk sky130_fd_sc_hd__clkbuf_16
XFILLER_0_26_41 VGND VGND VPWR VPWR sky130_fd_sc_hd__decap_4
XFILLER_0_22_165 VGND VGND VPWR VPWR sky130_fd_sc_hd__decap_6
X_475_ _192_ _189_ _227_ _187_ VGND VGND VPWR VPWR _011_ sky130_fd_sc_hd__a31o_1
XPHY_55 VGND VGND VPWR VPWR sky130_fd_sc_hd__decap_3
XPHY_44 VGND VGND VPWR VPWR sky130_fd_sc_hd__decap_3
XPHY_33 VGND VGND VPWR VPWR sky130_fd_sc_hd__decap_3
XFILLER_0_13_165 VGND VGND VPWR VPWR sky130_fd_sc_hd__decap_3
XPHY_11 VGND VGND VPWR VPWR sky130_fd_sc_hd__decap_3
X_260_ _195_ _196_ _197_ _200_ VGND VGND VPWR VPWR _210_ sky130_fd_sc_hd__o31a_1
XPHY_22 VGND VGND VPWR VPWR sky130_fd_sc_hd__decap_3
X_458_ _159_ _169_ _171_ _178_ VGND VGND VPWR VPWR _179_ sky130_fd_sc_hd__a22o_1
X_389_ _108_ _111_ VGND VGND VPWR VPWR _112_ sky130_fd_sc_hd__or2_1
Xinput18 threshold[3] VGND VGND VPWR VPWR net18 sky130_fd_sc_hd__buf_1
X_243_ net6 VGND VGND VPWR VPWR _193_ sky130_fd_sc_hd__clkbuf_4
X_312_ _236_ _033_ _024_ _026_ VGND VGND VPWR VPWR _035_ sky130_fd_sc_hd__o211a_1
XFILLER_0_2_165 VGND VGND VPWR VPWR sky130_fd_sc_hd__fill_2
XFILLER_0_2_121 VPWR VGND VPWR VGND sky130_ef_sc_hd__decap_12
XFILLER_0_3_63 VPWR VGND VPWR VGND sky130_ef_sc_hd__decap_12
XFILLER_0_26_9 VPWR VGND VPWR VGND sky130_ef_sc_hd__decap_12
XFILLER_0_18_64 VGND VGND VPWR VPWR sky130_fd_sc_hd__decap_4
XFILLER_0_18_42 VGND VGND VPWR VPWR sky130_fd_sc_hd__decap_6
Xhold7 net29 VGND VGND VPWR VPWR net46 sky130_fd_sc_hd__dlygate4sd3_1
XFILLER_0_20_76 VGND VGND VPWR VPWR sky130_fd_sc_hd__decap_8
XFILLER_0_20_43 VPWR VGND VPWR VGND sky130_ef_sc_hd__decap_12
XFILLER_0_0_97 VPWR VGND VPWR VGND sky130_ef_sc_hd__decap_12
X_491_ clknet_1_0__leaf_clk _012_ net39 VGND VGND VPWR VPWR net36 sky130_fd_sc_hd__dfrtp_1
XFILLER_0_9_95 VPWR VGND VPWR VGND sky130_ef_sc_hd__decap_12
XFILLER_0_22_3 VGND VGND VPWR VPWR sky130_fd_sc_hd__fill_2
XFILLER_0_16_141 VPWR VGND VPWR VGND sky130_ef_sc_hd__decap_12
XFILLER_0_16_130 VGND VGND VPWR VPWR sky130_fd_sc_hd__decap_8
X_474_ _190_ net47 VGND VGND VPWR VPWR _187_ sky130_fd_sc_hd__and2_1
XFILLER_0_13_111 VGND VGND VPWR VPWR sky130_fd_sc_hd__fill_1
XPHY_12 VGND VGND VPWR VPWR sky130_fd_sc_hd__decap_3
XPHY_56 VGND VGND VPWR VPWR sky130_fd_sc_hd__decap_3
XPHY_45 VGND VGND VPWR VPWR sky130_fd_sc_hd__decap_3
XPHY_34 VGND VGND VPWR VPWR sky130_fd_sc_hd__decap_3
XPHY_23 VGND VGND VPWR VPWR sky130_fd_sc_hd__decap_3
X_457_ _151_ _177_ VGND VGND VPWR VPWR _178_ sky130_fd_sc_hd__xnor2_1
XFILLER_0_12_66 VGND VGND VPWR VPWR sky130_fd_sc_hd__fill_1
X_388_ _109_ _110_ VGND VGND VPWR VPWR _111_ sky130_fd_sc_hd__xnor2_1
Xinput19 threshold[4] VGND VGND VPWR VPWR net19 sky130_fd_sc_hd__buf_1
X_311_ _024_ _026_ _236_ _033_ VGND VGND VPWR VPWR _034_ sky130_fd_sc_hd__a211oi_1
X_242_ net7 VGND VGND VPWR VPWR _192_ sky130_fd_sc_hd__clkbuf_4
XFILLER_0_23_54 VGND VGND VPWR VPWR sky130_fd_sc_hd__fill_2
XFILLER_0_2_133 VGND VGND VPWR VPWR sky130_fd_sc_hd__decap_6
XFILLER_0_3_75 VPWR VGND VPWR VGND sky130_ef_sc_hd__decap_12
XFILLER_0_19_9 VGND VGND VPWR VPWR sky130_fd_sc_hd__fill_2
Xhold8 net35 VGND VGND VPWR VPWR net47 sky130_fd_sc_hd__dlygate4sd3_1
XFILLER_0_0_76 VGND VGND VPWR VPWR sky130_fd_sc_hd__decap_8
X_490_ clknet_1_0__leaf_clk _011_ net39 VGND VGND VPWR VPWR net35 sky130_fd_sc_hd__dfrtp_1
XFILLER_0_25_120 VPWR VGND VPWR VGND sky130_ef_sc_hd__decap_12
XFILLER_0_15_44 VGND VGND VPWR VPWR sky130_fd_sc_hd__fill_1
XFILLER_0_16_153 VPWR VGND VPWR VGND sky130_ef_sc_hd__decap_12
X_473_ _193_ _189_ _227_ _186_ VGND VGND VPWR VPWR _010_ sky130_fd_sc_hd__a31o_1
XFILLER_0_26_21 VGND VGND VPWR VPWR sky130_fd_sc_hd__decap_6
XFILLER_0_6_97 VGND VGND VPWR VPWR sky130_fd_sc_hd__decap_3
XPHY_57 VGND VGND VPWR VPWR sky130_fd_sc_hd__decap_3
XPHY_46 VGND VGND VPWR VPWR sky130_fd_sc_hd__decap_3
XPHY_35 VGND VGND VPWR VPWR sky130_fd_sc_hd__decap_3
XPHY_13 VGND VGND VPWR VPWR sky130_fd_sc_hd__decap_3
XPHY_24 VGND VGND VPWR VPWR sky130_fd_sc_hd__decap_3
X_456_ _161_ _131_ _163_ VGND VGND VPWR VPWR _177_ sky130_fd_sc_hd__o21a_1
X_387_ _089_ _088_ VGND VGND VPWR VPWR _110_ sky130_fd_sc_hd__and2b_1
XFILLER_0_12_89 VGND VGND VPWR VPWR sky130_fd_sc_hd__fill_1
X_310_ _234_ _235_ _233_ VGND VGND VPWR VPWR _033_ sky130_fd_sc_hd__a21oi_1
XFILLER_0_5_131 VPWR VGND VPWR VGND sky130_ef_sc_hd__decap_12
X_439_ _161_ _131_ VGND VGND VPWR VPWR _162_ sky130_fd_sc_hd__nor2_1
X_241_ _190_ VGND VGND VPWR VPWR _191_ sky130_fd_sc_hd__clkbuf_4
XFILLER_0_3_54 VGND VGND VPWR VPWR sky130_fd_sc_hd__fill_2
XFILLER_0_3_43 VGND VGND VPWR VPWR sky130_fd_sc_hd__decap_6
XFILLER_0_3_87 VPWR VGND VPWR VGND sky130_ef_sc_hd__decap_12
Xhold9 net30 VGND VGND VPWR VPWR net48 sky130_fd_sc_hd__dlygate4sd3_1
XFILLER_0_20_34 VGND VGND VPWR VPWR sky130_fd_sc_hd__fill_2
XFILLER_0_9_53 VGND VGND VPWR VPWR sky130_fd_sc_hd__decap_3
XFILLER_0_19_151 VPWR VGND VPWR VGND sky130_ef_sc_hd__decap_12
XFILLER_0_25_132 VPWR VGND VPWR VGND sky130_ef_sc_hd__decap_12
XFILLER_0_25_110 VGND VGND VPWR VPWR sky130_fd_sc_hd__fill_2
XFILLER_0_16_110 VGND VGND VPWR VPWR sky130_fd_sc_hd__decap_8
XFILLER_0_16_165 VGND VGND VPWR VPWR sky130_fd_sc_hd__decap_6
X_472_ _190_ net51 VGND VGND VPWR VPWR _186_ sky130_fd_sc_hd__and2_1
XFILLER_0_9_107 VGND VGND VPWR VPWR sky130_fd_sc_hd__decap_4
XPHY_47 VGND VGND VPWR VPWR sky130_fd_sc_hd__decap_3
XPHY_36 VGND VGND VPWR VPWR sky130_fd_sc_hd__decap_3
XPHY_25 VGND VGND VPWR VPWR sky130_fd_sc_hd__decap_3
XPHY_14 VGND VGND VPWR VPWR sky130_fd_sc_hd__decap_3
XFILLER_0_6_65 VGND VGND VPWR VPWR sky130_fd_sc_hd__fill_2
X_455_ _191_ net43 _228_ _176_ VGND VGND VPWR VPWR _002_ sky130_fd_sc_hd__a22o_1
X_386_ _030_ _194_ VGND VGND VPWR VPWR _109_ sky130_fd_sc_hd__nand2_1
XFILLER_0_5_143 VPWR VGND VPWR VGND sky130_ef_sc_hd__decap_12
X_240_ _189_ VGND VGND VPWR VPWR _190_ sky130_fd_sc_hd__inv_2
X_438_ _100_ _123_ VGND VGND VPWR VPWR _161_ sky130_fd_sc_hd__and2_1
XFILLER_0_3_99 VPWR VGND VPWR VGND sky130_ef_sc_hd__decap_12
X_369_ _079_ _081_ _080_ VGND VGND VPWR VPWR _092_ sky130_fd_sc_hd__a21bo_1
XFILLER_0_18_89 VGND VGND VPWR VPWR sky130_fd_sc_hd__fill_1
XFILLER_0_28_141 VGND VGND VPWR VPWR sky130_fd_sc_hd__fill_2
XFILLER_0_19_163 VGND VGND VPWR VPWR sky130_fd_sc_hd__decap_4
XFILLER_0_25_144 VPWR VGND VPWR VGND sky130_ef_sc_hd__decap_12
XFILLER_0_15_57 VGND VGND VPWR VPWR sky130_fd_sc_hd__fill_1
X_471_ _194_ _189_ _227_ _185_ VGND VGND VPWR VPWR _009_ sky130_fd_sc_hd__a31o_1
XFILLER_0_26_78 VGND VGND VPWR VPWR sky130_fd_sc_hd__decap_3
XPHY_48 VGND VGND VPWR VPWR sky130_fd_sc_hd__decap_3
XFILLER_0_20_3 VGND VGND VPWR VPWR sky130_fd_sc_hd__decap_4
XPHY_37 VGND VGND VPWR VPWR sky130_fd_sc_hd__decap_3
XFILLER_0_13_169 VGND VGND VPWR VPWR sky130_fd_sc_hd__fill_2
XFILLER_0_13_103 VGND VGND VPWR VPWR sky130_fd_sc_hd__decap_8
XPHY_26 VGND VGND VPWR VPWR sky130_fd_sc_hd__decap_3
XPHY_15 VGND VGND VPWR VPWR sky130_fd_sc_hd__decap_3
XFILLER_0_8_130 VGND VGND VPWR VPWR sky130_fd_sc_hd__decap_8
XFILLER_0_8_141 VPWR VGND VPWR VGND sky130_ef_sc_hd__decap_12
X_454_ _151_ _171_ _175_ _159_ _169_ VGND VGND VPWR VPWR _176_ sky130_fd_sc_hd__a32o_1
X_385_ _104_ _107_ VGND VGND VPWR VPWR _108_ sky130_fd_sc_hd__or2b_1
XFILLER_0_10_139 VGND VGND VPWR VPWR sky130_fd_sc_hd__fill_1
XTAP_150 VGND VPWR sky130_fd_sc_hd__tapvpwrvgnd_1
XFILLER_0_5_155 VPWR VGND VPWR VGND sky130_ef_sc_hd__decap_12
X_437_ _140_ net38 _157_ VGND VGND VPWR VPWR _160_ sky130_fd_sc_hd__a21oi_2
XFILLER_0_23_68 VGND VGND VPWR VPWR sky130_fd_sc_hd__fill_1
X_299_ _016_ _192_ _019_ _021_ VGND VGND VPWR VPWR _022_ sky130_fd_sc_hd__nand4_2
X_368_ _071_ _069_ _070_ VGND VGND VPWR VPWR _091_ sky130_fd_sc_hd__nand3_1
XFILLER_0_18_68 VGND VGND VPWR VPWR sky130_fd_sc_hd__fill_1
XFILLER_0_0_57 VPWR VGND VPWR VGND sky130_ef_sc_hd__decap_12
XFILLER_0_0_35 VPWR VGND VPWR VGND sky130_ef_sc_hd__decap_12
XFILLER_0_25_156 VGND VGND VPWR VPWR sky130_fd_sc_hd__fill_2
XFILLER_0_15_25 VGND VGND VPWR VPWR sky130_fd_sc_hd__decap_3
X_470_ _191_ net50 VGND VGND VPWR VPWR _185_ sky130_fd_sc_hd__and2_1
XPHY_49 VGND VGND VPWR VPWR sky130_fd_sc_hd__decap_3
XPHY_38 VGND VGND VPWR VPWR sky130_fd_sc_hd__decap_3
XPHY_27 VGND VGND VPWR VPWR sky130_fd_sc_hd__decap_3
XFILLER_0_13_3 VGND VGND VPWR VPWR sky130_fd_sc_hd__decap_6
XPHY_16 VGND VGND VPWR VPWR sky130_fd_sc_hd__decap_3
XFILLER_0_8_153 VPWR VGND VPWR VGND sky130_ef_sc_hd__decap_12
X_453_ _149_ _150_ VGND VGND VPWR VPWR _175_ sky130_fd_sc_hd__or2_1
X_384_ _104_ _105_ _106_ VGND VGND VPWR VPWR _107_ sky130_fd_sc_hd__or3_1
XFILLER_0_12_15 VGND VGND VPWR VPWR sky130_fd_sc_hd__decap_8
XFILLER_0_5_167 VGND VGND VPWR VPWR sky130_fd_sc_hd__fill_1
XTAP_140 VGND VPWR sky130_fd_sc_hd__tapvpwrvgnd_1
XFILLER_0_2_3 VPWR VGND VPWR VGND sky130_ef_sc_hd__decap_12
X_436_ _049_ _158_ VGND VGND VPWR VPWR _159_ sky130_fd_sc_hd__nand2_2
X_298_ _020_ _193_ _194_ net14 VGND VGND VPWR VPWR _021_ sky130_fd_sc_hd__a22o_1
X_367_ _030_ _194_ _088_ _089_ VGND VGND VPWR VPWR _090_ sky130_fd_sc_hd__a31o_1
XFILLER_0_13_91 VGND VGND VPWR VPWR sky130_fd_sc_hd__decap_6
X_419_ _128_ _133_ VGND VGND VPWR VPWR _142_ sky130_fd_sc_hd__xnor2_2
XFILLER_0_28_121 VGND VGND VPWR VPWR sky130_fd_sc_hd__fill_1
XFILLER_0_0_69 VGND VGND VPWR VPWR sky130_fd_sc_hd__decap_4
XFILLER_0_0_47 VGND VGND VPWR VPWR sky130_fd_sc_hd__decap_3
XFILLER_0_0_14 VPWR VGND VPWR VGND sky130_ef_sc_hd__decap_12
XFILLER_0_9_45 VGND VGND VPWR VPWR sky130_fd_sc_hd__decap_8
XFILLER_0_9_67 VGND VGND VPWR VPWR sky130_fd_sc_hd__decap_6
XFILLER_0_9_78 VGND VGND VPWR VPWR sky130_fd_sc_hd__decap_6
XFILLER_0_22_127 VPWR VGND VPWR VGND sky130_ef_sc_hd__decap_12
XPHY_28 VGND VGND VPWR VPWR sky130_fd_sc_hd__decap_3
XPHY_17 VGND VGND VPWR VPWR sky130_fd_sc_hd__decap_3
XPHY_39 VGND VGND VPWR VPWR sky130_fd_sc_hd__decap_3
X_452_ _191_ net40 _228_ _174_ VGND VGND VPWR VPWR _001_ sky130_fd_sc_hd__a22o_1
XFILLER_0_8_165 VGND VGND VPWR VPWR sky130_fd_sc_hd__decap_6
X_383_ _101_ _103_ _102_ VGND VGND VPWR VPWR _106_ sky130_fd_sc_hd__a21oi_1
XFILLER_0_10_119 VPWR VGND VPWR VGND sky130_ef_sc_hd__decap_12
XTAP_141 VGND VPWR sky130_fd_sc_hd__tapvpwrvgnd_1
XTAP_130 VGND VPWR sky130_fd_sc_hd__tapvpwrvgnd_1
XFILLER_0_5_113 VGND VGND VPWR VPWR sky130_fd_sc_hd__decap_4
X_435_ _140_ net38 _157_ VGND VGND VPWR VPWR _158_ sky130_fd_sc_hd__nand3_2
X_297_ net13 VGND VGND VPWR VPWR _020_ sky130_fd_sc_hd__buf_2
X_366_ _084_ _087_ _082_ _083_ VGND VGND VPWR VPWR _089_ sky130_fd_sc_hd__o211a_1
XFILLER_0_18_59 VGND VGND VPWR VPWR sky130_fd_sc_hd__fill_1
XFILLER_0_18_48 VGND VGND VPWR VPWR sky130_fd_sc_hd__fill_1
XFILLER_0_18_15 VPWR VGND VPWR VGND sky130_ef_sc_hd__decap_12
X_418_ _131_ VGND VGND VPWR VPWR _141_ sky130_fd_sc_hd__inv_2
X_349_ _069_ _070_ _071_ VGND VGND VPWR VPWR _072_ sky130_fd_sc_hd__a21bo_1
XFILLER_0_24_91 VPWR VGND VPWR VGND sky130_ef_sc_hd__decap_12
XFILLER_0_28_111 VGND VGND VPWR VPWR sky130_fd_sc_hd__fill_1
XFILLER_0_20_27 VGND VGND VPWR VPWR sky130_fd_sc_hd__fill_1
XFILLER_0_0_26 VGND VGND VPWR VPWR sky130_fd_sc_hd__fill_2
XFILLER_0_19_91 VGND VGND VPWR VPWR sky130_fd_sc_hd__decap_4
XFILLER_0_9_57 VGND VGND VPWR VPWR sky130_fd_sc_hd__fill_1
XFILLER_0_25_169 VGND VGND VPWR VPWR sky130_fd_sc_hd__fill_2
XFILLER_0_15_38 VGND VGND VPWR VPWR sky130_fd_sc_hd__decap_6
XFILLER_0_22_139 VGND VGND VPWR VPWR sky130_fd_sc_hd__fill_1
XFILLER_0_26_59 VGND VGND VPWR VPWR sky130_fd_sc_hd__fill_1
XFILLER_0_6_36 VGND VGND VPWR VPWR sky130_fd_sc_hd__decap_3
XPHY_29 VGND VGND VPWR VPWR sky130_fd_sc_hd__decap_3
XPHY_18 VGND VGND VPWR VPWR sky130_fd_sc_hd__decap_3
X_451_ _159_ _169_ _171_ _173_ VGND VGND VPWR VPWR _174_ sky130_fd_sc_hd__a22o_1
X_382_ _030_ net4 VGND VGND VPWR VPWR _105_ sky130_fd_sc_hd__nand2_1
XTAP_142 VGND VPWR sky130_fd_sc_hd__tapvpwrvgnd_1
XTAP_131 VGND VPWR sky130_fd_sc_hd__tapvpwrvgnd_1
XTAP_120 VGND VPWR sky130_fd_sc_hd__tapvpwrvgnd_1
XFILLER_0_5_169 VGND VGND VPWR VPWR sky130_fd_sc_hd__fill_2
X_434_ _153_ _154_ _155_ _156_ VGND VGND VPWR VPWR _157_ sky130_fd_sc_hd__a211o_1
X_296_ _230_ _231_ _193_ _194_ VGND VGND VPWR VPWR _019_ sky130_fd_sc_hd__nand4_2
XFILLER_0_7_90 VGND VGND VPWR VPWR sky130_fd_sc_hd__fill_2
X_365_ _082_ _083_ _084_ _087_ VGND VGND VPWR VPWR _088_ sky130_fd_sc_hd__a211o_1
XFILLER_0_3_15 VGND VGND VPWR VPWR sky130_fd_sc_hd__decap_8
XFILLER_0_2_139 VGND VGND VPWR VPWR sky130_fd_sc_hd__fill_1
XFILLER_0_1_161 VGND VGND VPWR VPWR sky130_fd_sc_hd__decap_6
X_417_ _063_ _139_ VGND VGND VPWR VPWR _140_ sky130_fd_sc_hd__xnor2_2
XFILLER_0_18_27 VGND VGND VPWR VPWR sky130_fd_sc_hd__fill_1
X_348_ net14 _020_ net4 net3 VGND VGND VPWR VPWR _071_ sky130_fd_sc_hd__nand4_1
X_279_ net41 _189_ _228_ VGND VGND VPWR VPWR _000_ sky130_fd_sc_hd__o21ba_1
XFILLER_0_19_167 VGND VGND VPWR VPWR sky130_fd_sc_hd__fill_1
XFILLER_0_15_17 VGND VGND VPWR VPWR sky130_fd_sc_hd__fill_2
XFILLER_0_15_9 VGND VGND VPWR VPWR sky130_fd_sc_hd__decap_8
XFILLER_0_22_107 VGND VGND VPWR VPWR sky130_fd_sc_hd__decap_3
XFILLER_0_21_93 VGND VGND VPWR VPWR sky130_fd_sc_hd__fill_2
XFILLER_0_1_81 VPWR VGND VPWR VGND sky130_ef_sc_hd__decap_12
XFILLER_0_26_27 VGND VGND VPWR VPWR sky130_fd_sc_hd__fill_1
XFILLER_0_13_129 VPWR VGND VPWR VGND sky130_ef_sc_hd__decap_12
XFILLER_0_16_82 VGND VGND VPWR VPWR sky130_fd_sc_hd__fill_2
XFILLER_0_4_9 VPWR VGND VPWR VGND sky130_ef_sc_hd__decap_12
XPHY_19 VGND VGND VPWR VPWR sky130_fd_sc_hd__decap_3
X_450_ _149_ _172_ VGND VGND VPWR VPWR _173_ sky130_fd_sc_hd__nor2_1
X_381_ _101_ _102_ _103_ VGND VGND VPWR VPWR _104_ sky130_fd_sc_hd__and3_1
XTAP_143 VGND VPWR sky130_fd_sc_hd__tapvpwrvgnd_1
XTAP_132 VGND VPWR sky130_fd_sc_hd__tapvpwrvgnd_1
XTAP_121 VGND VPWR sky130_fd_sc_hd__tapvpwrvgnd_1
XTAP_110 VGND VPWR sky130_fd_sc_hd__tapvpwrvgnd_1
X_433_ _060_ _062_ _078_ _137_ VGND VGND VPWR VPWR _156_ sky130_fd_sc_hd__o211a_1
X_295_ _016_ _237_ _017_ _238_ VGND VGND VPWR VPWR _018_ sky130_fd_sc_hd__a22o_1
X_364_ _016_ _195_ _085_ _086_ VGND VGND VPWR VPWR _087_ sky130_fd_sc_hd__and4_1
XFILLER_0_13_61 VGND VGND VPWR VPWR sky130_fd_sc_hd__decap_8
X_416_ _078_ _137_ _138_ VGND VGND VPWR VPWR _139_ sky130_fd_sc_hd__a21oi_1
X_347_ net13 net4 net3 net14 VGND VGND VPWR VPWR _070_ sky130_fd_sc_hd__a22o_1
X_278_ _191_ _227_ VGND VGND VPWR VPWR _228_ sky130_fd_sc_hd__nor2_2
XFILLER_0_28_113 VGND VGND VPWR VPWR sky130_fd_sc_hd__decap_8
XFILLER_0_9_15 VPWR VGND VPWR VGND sky130_ef_sc_hd__decap_12
XFILLER_0_19_113 VGND VGND VPWR VPWR sky130_fd_sc_hd__decap_3
XFILLER_0_16_138 VGND VGND VPWR VPWR sky130_fd_sc_hd__fill_2
XFILLER_0_1_93 VPWR VGND VPWR VGND sky130_ef_sc_hd__decap_12
XFILLER_0_12_141 VPWR VGND VPWR VGND sky130_ef_sc_hd__decap_12
X_380_ net12 _195_ _085_ _086_ VGND VGND VPWR VPWR _103_ sky130_fd_sc_hd__a22o_1
Xoutput30 net30 VGND VGND VPWR VPWR sideband_out[1] sky130_fd_sc_hd__buf_2
XTAP_144 VGND VPWR sky130_fd_sc_hd__tapvpwrvgnd_1
XTAP_133 VGND VPWR sky130_fd_sc_hd__tapvpwrvgnd_1
XTAP_122 VGND VPWR sky130_fd_sc_hd__tapvpwrvgnd_1
XTAP_111 VGND VPWR sky130_fd_sc_hd__tapvpwrvgnd_1
XTAP_100 VGND VPWR sky130_fd_sc_hd__tapvpwrvgnd_1
.ends
